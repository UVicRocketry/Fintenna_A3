# Ansys Electronics Desktop project, version 2025.2
project variables:
  $Radius = 73mm
  $length = 16mm
  $width = 16mm
  $Indent = 7mm
  $QuarterWavelength = 47.619mm
  $SideLength = 34mm
  $CopperHeight = 0.035mm
  $FeedlineWidth = 3.627mm
  $xsize = 40mm
  $ysize = 40mm
  $stubLength = 6.92003081mm
  $FeedlineLength = 28.7874mm
materials:
  vacuum: permittivity=1
  copper: permeability=0.999991 conductivity=58000000
  air: permittivity=1.0006 permeability=1.0000004
  graphite: conductivity=70000
  FR4_epoxy: permittivity=4.4 dielectric_loss_tangent=0.02
  cast_iron: permeability=60 conductivity=1500000
  CF - Carbon fiber: conductivity=252.337
  aluminum: permeability=1.000021 conductivity=38000000
  cyanate_ester: permittivity=3.8

design HFSSDesign1 (HFSS, HFSS Terminal Network, model units mm)
geometry:
  Substrate [FR4_epoxy] = box(corner=(48mm, $Radius, 0.8mm), size=((-4.25*25) mm, 48mm, -1.6mm))
  Fuselage [CF - Carbon fiber] = cylinder(axis=X, base_centre=(-200mm, 0mm, 0mm), radius=73mm, height=400mm, segments=32)
  Cylinder3 = cylinder(axis=X, base_centre=(200mm, 0mm, 0mm), radius=70.6mm, height=-400mm)
  Fuselage.subtract(Cylinder3)
  Box13 [air] = box(corner=(-250mm, 200mm, 100mm), size=(500mm, -400mm, -200mm))
  Coupler [aluminum, non-model] = cylinder(axis=X, base_centre=(-100mm, 0mm, 0mm), radius=70.6mm, height=200mm, segments=32)
  Cylinder5 = cylinder(axis=X, base_centre=(100mm, 0mm, 0mm), radius=(70.6-3.175) mm, height=-200mm)
  Coupler.subtract(Cylinder5)
  Substrate.chamfer(Edges=Substrate.edge(at (-58.25, 121, 0)) LeftDistance=48mm RightDistance="(2.25*25) mm" ChamferType="Left Distance-Right Distance" ChamferAdditionalGeometryInfo{ChamferEdgeGeometryInfo{ChamferEdgeID=1342 ChamferEdgeSense ChamferEdgeStart{X=-58.25mm Y=121mm Z=0.8mm} ChamferEdgeEnd{X=-58.25mm Y=121mm Z=-0.8mm} ChamferEdgeMid{X=-58.25mm Y=121mm Z=0mm} ChamferEdgeMidTangent(0, 0, -1)}})
  Substrate.chamfer(Edges=Substrate.edge(at (48, 121, 0)) LeftDistance=6.25mm RightDistance=48mm ChamferType="Left Distance-Right Distance" ChamferAdditionalGeometryInfo{ChamferEdgeGeometryInfo{ChamferEdgeID=1343 ChamferEdgeSense ChamferEdgeStart{X=48mm Y=121mm Z=0.8mm} ChamferEdgeEnd{X=48mm Y=121mm Z=-0.8mm} ChamferEdgeMid{X=48mm Y=121mm Z=0mm} ChamferEdgeMidTangent(0, 0, -1)}})
  Fintenna [cyanate_ester, non-model] = imported_body(C:\Users\Garrett W\Documents\[A3-FIN] fintenna_assembly\[A3-FIN] fintenna_assembly - Fintenna.step)
  Fintenna.rotate(axis=Z, angle=90deg)
  Fintenna.rotate(axis=Y, angle=-90deg)
  Fintenna.move(-62.5mm, 73mm, -2.38125mm)
  Box14 = box(corner=(-58.25mm, 73mm, 0.8mm), size=(106.25mm, -12.065mm, -1.6mm))
  Substrate.unite(Box14)
  AntennaCut = box(corner=(48mm, $Radius, 0.835mm), size=((-4.25*25) mm, 48mm, -1.67mm))
  AntennaCut.chamfer(Edges=AntennaCut.edge(at (-58.25, 121, 0)) LeftDistance=48mm RightDistance="(2.25*25) mm" ChamferType="Left Distance-Right Distance" ChamferAdditionalGeometryInfo{ChamferEdgeGeometryInfo{ChamferEdgeID=3003 ChamferEdgeSense ChamferEdgeStart{X=-58.25mm Y=121mm Z=0.835mm} ChamferEdgeEnd{X=-58.25mm Y=121mm Z=-0.835mm} ChamferEdgeMid{X=-58.25mm Y=121mm Z=0mm} ChamferEdgeMidTangent(0, 0, -1)}})
  AntennaCut.chamfer(Edges=AntennaCut.edge(at (48, 121, 0)) LeftDistance=6.25mm RightDistance=48mm ChamferType="Left Distance-Right Distance" ChamferAdditionalGeometryInfo{ChamferEdgeGeometryInfo{ChamferEdgeID=3004 ChamferEdgeSense ChamferEdgeStart{X=48mm Y=121mm Z=0.835mm} ChamferEdgeEnd{X=48mm Y=121mm Z=-0.835mm} ChamferEdgeMid{X=48mm Y=121mm Z=0mm} ChamferEdgeMidTangent(0, 0, -1)}})
  Box15 = box(corner=(-58.25mm, 73mm, 0.835mm), size=(106.25mm, -12.065mm, -1.67mm))
  AntennaCut.unite(Box15)
  Fintenna.subtract(AntennaCut)
  Fintenna_1 = Fintenna.copy()
  Substrate_1 = Substrate.copy()
  Fuselage.subtract(Fintenna_1, Substrate_1)
  FinFoot1 [aluminum, non-model] = imported_body(C:\Users\Garrett W\Documents\[A3-FIN] fintenna_assembly\[A3-FIN] fintenna_assembly - Part 1.step)
  FinFoot [aluminum, non-model] = imported_body(C:\Users\Garrett W\Documents\[A3-FIN] fintenna_assembly\[A3-FIN] fintenna_assembly - Part 2.step)
  FinFoot1.rotate(axis=Y, angle=-90deg)
  FinFoot1.rotate(axis=Z, angle=90deg)
  FinFoot1.move(-62.5mm, 70.46mm, 2.38125mm)
  FinFoot.rotate(axis=Y, angle=-90deg)
  FinFoot.rotate(axis=Z, angle=90deg)
  FinFoot.move(-62.5mm, 70.46mm, 7.16915mm)
  CutTool [FR4_epoxy, non-model] = box(corner=(48mm, $Radius, 0.835mm), size=((-4.25*25) mm, 48mm, -1.67mm))
  CutTool.chamfer(Edges=CutTool.edge(at (-58.25, 121, 0)) LeftDistance=48mm RightDistance="(2.25*25) mm" ChamferType="Left Distance-Right Distance" ChamferAdditionalGeometryInfo{ChamferEdgeGeometryInfo{ChamferEdgeID=4487 ChamferEdgeSense ChamferEdgeStart{X=-58.25mm Y=121mm Z=0.835mm} ChamferEdgeEnd{X=-58.25mm Y=121mm Z=-0.835mm} ChamferEdgeMid{X=-58.25mm Y=121mm Z=0mm} ChamferEdgeMidTangent(0, 0, -1)}})
  CutTool.chamfer(Edges=CutTool.edge(at (48, 121, 0)) LeftDistance=6.25mm RightDistance=48mm ChamferType="Left Distance-Right Distance" ChamferAdditionalGeometryInfo{ChamferEdgeGeometryInfo{ChamferEdgeID=4488 ChamferEdgeSense ChamferEdgeStart{X=48mm Y=121mm Z=0.835mm} ChamferEdgeEnd{X=48mm Y=121mm Z=-0.835mm} ChamferEdgeMid{X=48mm Y=121mm Z=0mm} ChamferEdgeMidTangent(0, 0, -1)}})
  Box16 = box(corner=(-58.25mm, 73mm, 0.835mm), size=(106.25mm, -12.065mm, -1.67mm))
  CutTool.unite(Box16)
  CutTool_1 = CutTool.copy()
  FinFoot_1 = FinFoot.copy()
  FinFoot1_1 = FinFoot1.copy()
  Fintenna_2 = Fintenna.copy()
  Coupler.subtract(CutTool_1, FinFoot_1, FinFoot1_1, Fintenna_2)
  CutTool_2 = CutTool.copy()
  FinFoot_2 = FinFoot.copy()
  FinFoot1_2 = FinFoot1.copy()
  Fintenna_3 = Fintenna.copy()
  Fuselage.subtract(CutTool_2, FinFoot_2, FinFoot1_2, Fintenna_3)
  FuselageEdge = polyline((-58.25mm, 73mm, 0.835mm) (48mm, 73mm, 0.835mm))
  coordinate_system RelativeCS1 = origin=(-5.125mm, 73mm, 0.835mm) x=(1mm, 0mm, 0mm) y=(0mm, 1mm, 0mm)
  coordinate_system RelativeCS7 = origin=(5mm, (5+ 3.110507) mm, -0.035mm) x=(1mm, 0mm, 0mm) y=(0mm, 1mm, 0mm) in RelativeCS1
  coordinate_system RelativeCS9 = origin=(2.495793mm, -20.175507mm, -1.6175mm) x=(1mm, 0mm, 0mm) y=(0mm, 1mm, 0mm) in RelativeCS7
  coordinate_system RelativeCS10 = origin=(0mm, 0mm, 0.0175mm) x=(1mm, 0mm, 0mm) y=(0mm, 1mm, 0mm) in RelativeCS9
  coordinate_system RelativeCS11 = origin=(-2.495793mm, 19.268757mm, 1.6mm) x=(1mm, 0mm, 0mm) y=(0mm, 1mm, 0mm) in RelativeCS10
  coordinate_system RelativeCS12 = origin=(0mm, 0.40675mm, 0mm) x=(1mm, 0mm, 0mm) y=(0mm, 1mm, 0mm) in RelativeCS11
  coordinate_system RelativeCS13 = origin=(0.5mm, 0.5mm, 0mm) x=(1mm, 0mm, 0mm) y=(0mm, 1mm, 0mm) in RelativeCS12
  Slot = box(corner=(-$FeedlineWidth/2, -$FeedlineWidth/2, $CopperHeight), size=($SideLength+$FeedlineWidth, $SideLength+$FeedlineWidth, $CopperHeight)) in RelativeCS13
  Box18 = box(corner=(0, 0, $CopperHeight), size=($SideLength, $SideLength, $CopperHeight)) in RelativeCS13
  Slot.subtract(Box18)
  coordinate_system RelativeCS2 = origin=(7.5mm, 8.1641411mm, 0.0175mm) x=(1mm, 0mm, 0mm) y=(0mm, 1mm, 0mm) in RelativeCS1
  coordinate_system RelativeCS3 = origin=(0mm, 0mm, -0.0175mm) x=(1mm, 0mm, 0mm) y=(0mm, 1mm, 0mm) in RelativeCS2
  plane Plane1 = base (17.271035mm, 17.267832mm, 0mm) normal (0.1030138mm, -0.30409192mm, 0mm) in RelativeCS3
  GroundPlane [copper] = polyline(z=0mm, xy in mm: (39.375, 39.835859) (-4.375, 39.835859) (-60.625, -8.1641411) (-60.625, -20.229141) (45.625, -20.229141) (45.625, -8.1641411) (39.375, 39.835859), closed, covered) in RelativeCS3
  GroundPlane.sweep_along_vector((0mm, 0mm, $CopperHeight)) in RelativeCS3
  GroundPlane.subtract(Slot)
  GroundPlane.move(0mm, 0mm, -$CopperHeight) in RelativeCS3
  coordinate_system RelativeCS4 = origin=(-1.785235mm, -20.229141mm, -1.635mm) x=(1mm, 0mm, 0mm) y=(0mm, 1mm, 0mm) in RelativeCS3
  coordinate_system RelativeCS5 = origin=(5mm, 5.491765mm, -0.0175mm) x=(1mm, 0mm, 0mm) y=(0mm, 1mm, 0mm) in RelativeCS1
  coordinate_system RelativeCS6 = origin=(-1.785235mm, -17.556765mm, -1.6175mm) x=(1mm, 0mm, 0mm) y=(0mm, 1mm, 0mm) in RelativeCS5
  coordinate_system RelativeCS15 = origin=(-0.90675mm, -0.90675mm, 0.035mm) x=(1mm, 0mm, 0mm) y=(0mm, 1mm, 0mm) in RelativeCS13
  coordinate_system RelativeCS16 = origin=(0mm, 0mm, -0.035mm) x=(1mm, 0mm, 0mm) y=(0mm, 1mm, 0mm) in RelativeCS15
  StubCutOut = box(corner=(-$FeedlineWidth/4, $SideLength/2-3*$FeedlineWidth/4 +$FeedlineWidth/4, 0mm), size=($stubLength+$FeedlineWidth/2, 3*$FeedlineWidth/2, $CopperHeight)) in RelativeCS16
  Stub = box(corner=(-$FeedlineWidth/4, $SideLength/2, 0mm), size=($stubLength, $FeedlineWidth/2, $CopperHeight)) in RelativeCS16
  Stub_1 = Stub.duplicate_along_line(step=($SideLength+$FeedlineWidth-$stubLength, 0mm, 0mm), total=2) in RelativeCS16
  StubCutOut_1 = StubCutOut.duplicate_along_line(step=($SideLength-$stubLength+$FeedlineWidth/2, 0mm, 0mm), total=2) in RelativeCS16
  StubCutOut_2 = box(corner=($SideLength/2-3*$FeedlineWidth/4+$FeedlineWidth/4, -$FeedlineWidth/4, 0mm), size=(3*$FeedlineWidth/2, $stubLength+$FeedlineWidth/2, $CopperHeight)) in RelativeCS16
  Stub_2 = box(corner=($SideLength/2, -$FeedlineWidth/4, 0mm), size=($FeedlineWidth/2, $stubLength, $CopperHeight)) in RelativeCS16
  StubCutOut_2_1 = StubCutOut_2.duplicate_along_line(step=(0mm, $SideLength-$stubLength+$FeedlineWidth/2, 0mm), total=2) in RelativeCS16
  Stub_2_1 = Stub_2.duplicate_along_line(step=(0mm, $SideLength-$stubLength+$FeedlineWidth, 0mm), total=2) in RelativeCS16
  GroundPlane.subtract(StubCutOut, StubCutOut_1, StubCutOut_2, StubCutOut_2_1)
  GroundPlane.unite(Stub, Stub_1, Stub_2, Stub_2_1)
  coordinate_system RelativeCS8 = origin=(-1.785235mm, -17.065mm, -1.6mm) x=(1mm, 0mm, 0mm) y=(0mm, 1mm, 0mm) in RelativeCS7
  coordinate_system RelativeCS14 = origin=(-1.8135mm, -20.175507mm, -1.6mm) x=(1mm, 0mm, 0mm) y=(0mm, 1mm, 0mm) in RelativeCS13
  Rectangle1 = rectangle(corner=(0mm, 0mm, 0mm), z_size=1.6mm, x_size=$FeedlineWidth) in RelativeCS14
  Polyline1 = polyline((1mm, 1mm, 0mm) (0mm, 0mm, 0mm)) in RelativeCS12
  Stub1 = box(corner=(-1mm, -$FeedlineWidth/4, 0mm), size=($stubLength+2mm, $FeedlineWidth/2, $CopperHeight)) in RelativeCS16
  StubCutOut1 = box(corner=(3*$FeedlineWidth/4, -3*$FeedlineWidth/4, 0mm), size=($stubLength, 3*$FeedlineWidth/2, $CopperHeight)) in RelativeCS16
  [StubCutOut1, Stub1].rotate(axis=Z, angle=45deg) in RelativeCS16
  StubCutOut1_1 = StubCutOut1.duplicate_mirror(point=(0mm, 0mm, 0mm), normal=(1mm, 0mm, 0mm)) in RelativeCS16
  Stub1_1 = Stub1.duplicate_mirror(point=(0mm, 0mm, 0mm), normal=(1mm, 0mm, 0mm)) in RelativeCS16
  [Stub1_1, StubCutOut1_1].move($SideLength+$FeedlineWidth/2, 0mm, 0mm) in RelativeCS16
  StubCutOut1_1_1 = StubCutOut1_1.duplicate_mirror(point=(0mm, 0mm, 0mm), normal=(0mm, 1mm, 0mm)) in RelativeCS16
  Stub1_1_1 = Stub1_1.duplicate_mirror(point=(0mm, 0mm, 0mm), normal=(0mm, 1mm, 0mm)) in RelativeCS16
  [StubCutOut1_1_1, Stub1_1_1].move(0mm, $SideLength+$FeedlineWidth/2, 0mm) in RelativeCS16
  Stub1_2 = Stub1.duplicate_mirror(point=(0mm, 0mm, 0mm), normal=(0mm, 1mm, 0mm)) in RelativeCS16
  StubCutOut1_2 = StubCutOut1.duplicate_mirror(point=(0mm, 0mm, 0mm), normal=(0mm, 1mm, 0mm)) in RelativeCS16
  [StubCutOut1_2, Stub1_2].move(0mm, $SideLength+$FeedlineWidth/2, 0mm) in RelativeCS16
  GroundPlane.subtract(StubCutOut1, StubCutOut1_1, StubCutOut1_1_1, StubCutOut1_2)  # suppressed
  GroundPlane.unite(Stub1_2, Stub1_1_1, Stub1_1, Stub1)  # suppressed
  coordinate_system RelativeCS17 = origin=(0.90675mm, 0.90675mm, 0mm) x=(1mm, 0mm, 0mm) y=(0mm, 1mm, 0mm) in RelativeCS16
  Box19 = box(corner=(-$FeedlineWidth/2, 0, 0mm), size=($FeedlineWidth, $QuarterWavelength/2, $CopperHeight)) in RelativeCS17
  Box19.rotate(axis=Z, angle=-45deg) in RelativeCS17
  Feedline [copper] = Box19.duplicate_mirror(point=(0mm, 0mm, 0mm), normal=(1mm, 0mm, 0mm)) in RelativeCS17
  Feedline.move($SideLength, 0mm, 0mm) in RelativeCS17
  Feedline.unite(Box19)
  Polyline2 = polyline(z=0mm, xy in mm: (17, 16.671718) (15.553521, 18.118197) (18.446479, 18.118197) (17, 16.671718), closed, covered) in RelativeCS17
  Polyline2.sweep_along_vector((0mm, 0mm, $CopperHeight)) in RelativeCS17
  Feedline.unite(Polyline2)
  Box20 = box(corner=(-$FeedlineWidth/2, (-12.065-8.110571) mm, 0mm), size=($FeedlineWidth, (12.065+8.110571) mm, $CopperHeight)) in RelativeCS17
  Polyline3 = polyline(z=0mm, xy in mm: (-1.2823381, 1.2823381) (0, 0) (-1.8135, 0) (-1.2823381, 1.2823381), closed, covered) in RelativeCS17
  Polyline3.sweep_along_vector((0mm, 0mm, $CopperHeight)) in RelativeCS17
  Feedline.unite(Polyline3, Box20)
  Feedline.move(0mm, 0mm, -1.6mm-$CopperHeight) in RelativeCS17
  Feedline.mirror(point=(0mm, 0mm, 0mm), normal=(1mm, 0mm, 0mm)) in RelativeCS17
  [Feedline, Rectangle1].move($SideLength, 0mm, 0mm) in RelativeCS17
  group Fintenna1 = Fintenna
  group Part2 = FinFoot1
  group Part3 = FinFoot
boundaries and excitations:
  Rad1: Radiation Objects=Box13
  1_T1: Terminal port=1 Edges=Rectangle1.edge(at (34.375, 60.935, -0.8)) TerminalResistance=50ohm
  1: Lumped Port Faces=Rectangle1.face(at (34.375, 60.935, 0)) LumpedPortType=Terminal Impedance=50ohm
mesh:
  initial mesh: GlobalSurfApproximation{CurvedSurfaceApproxChoice=UseSlider SliderMeshSettings=3} MeshMethod=AnsoftTAU DynamicSurfaceResolution
setups:
  Setup1: HfssDriven Frequency=1.575GHz MaxDeltaS=0.02 MaximumPasses=6 MinimumPasses=1 MinimumConvergedPasses=1 PercentRefinement=30 BasisOrder=1 PortAccuracy=2 DrivenSolverType="Direct Solver"
    sweep Sweep: 1GHz to 2GHz, 401 points; Type=Interpolating SaveFields InterpTolerance=0.5 InterpMaxSolns=250 PassivityErrorTolerance=0.0001
source amplitudes:
  1:1: 1V 0deg
radiation setups:
  Infinite Sphere1: Infinite Sphere Theta=0deg..180deg step 2deg Phi=-180deg..180deg step 2deg
field plots:
  Mag_Jvol1: Jvol over GroundPlane.face(at (44.875, 97, 0.8175), at (-30.125, 97, 0.8175), at (-58.25, 66.9675, 0.8175), at (48, 66.9675, 0.8175)) on Setup1 : LastAdaptive at Freq=1.575GHz Phase=0deg
  Vector_Jsurf1: Jsurf over GroundPlane.face(at (44.875, 97, 0.8175), at (-30.125, 97, 0.8175), at (-58.25, 66.9675, 0.8175), at (48, 66.9675, 0.8175)) on Setup1 : LastAdaptive at Freq=1.575GHz Phase=0deg
reports:
  Total Gain Plot: dB(GainTotal) vs Phi, Theta on Setup1 : LastAdaptive, Infinite Sphere1 [Freq=1.575GHz]
  RHCP Gain Plot: dB(GainRHCP) vs Phi, Theta on Setup1 : LastAdaptive, Infinite Sphere1 [Freq=1.575GHz]
  Terminal VSWR Plot1: VSWRt(1) vs Freq on Setup1 : Sweep
  Axial Ratio Plot2: dB(AxialRatioValue) vs Freq on Setup1 : Sweep, Infinite Sphere1 [Phi=-180deg Theta=0deg]
  LHCP Gain Plot: dB(GainLHCP) vs Phi, Theta on Setup1 : LastAdaptive, Infinite Sphere1 [Freq=1.575GHz]
  Terminal S Parameter Plot1: dB(St(1_T1,1_T1)) vs Freq on Setup1 : Sweep
  Axial Ratio Plot2_1: dB(AxialRatioValue) vs Freq

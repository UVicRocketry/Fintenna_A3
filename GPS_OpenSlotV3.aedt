# Ansys Electronics Desktop project, version 2025.2
project variables:
  $Radius = 73mm
  $RadLen = (37.2+1.5) mm
  $RadWidth = 4mm
  $FeedX = 23mm
  $FeedY = 20mm
  $LineWidth = 1.47mm
  $TESTwidth = 1.5mm
  $TESTgap = 0.19mm
  $FeedOffset = 4.875mm  # optimise 2.5mm..7.5mm
  $Angle = 0deg
  $PlaneWidth = 8mm
  $FeedGap = 14.75mm
  $StubLen = 22mm
  $Chamfer = 8mm
  $BandSpacing = (5*25.4) mm
materials:
  vacuum: permittivity=1
  copper: permeability=0.999991 conductivity=58000000
  air: permittivity=1.0006 permeability=1.0000004
  graphite: conductivity=70000
  FR4_epoxy: permittivity=4.4 dielectric_loss_tangent=0.02
  cast_iron: permeability=60 conductivity=1500000
  CF - Carbon fiber: conductivity=252.337
  aluminum: permeability=1.000021 conductivity=38000000
  cyanate_ester: permittivity=3.8
  steel_stainless: conductivity=1100000
  nickel, DC: permeability=600 conductivity=14500000
  iron: permeability=4000 conductivity=10300000
  polyester: permittivity=3.2 dielectric_loss_tangent=0.003
  FR4_epoxy High Dielectric: permittivity=4.5 dielectric_loss_tangent=0.02

design HFSSDesign1 (HFSS, HFSS Terminal Network, model units mm)
geometry:
  Substrate [FR4_epoxy] = box(corner=(48mm, $Radius, 0.4mm), size=((-4.25*25) mm, 48mm, -0.8mm))
  Box13 [air] = box(corner=(-200mm, 200mm, 100mm), size=(400mm, -200mm, -200mm))
  Substrate.chamfer(Edges=Substrate.edge(at (-58.25, 121, 0)) LeftDistance=48mm RightDistance="(2.25*25) mm" ChamferType="Left Distance-Right Distance" ChamferAdditionalGeometryInfo{ChamferEdgeGeometryInfo{ChamferEdgeID=1342 ChamferEdgeSense ChamferEdgeStart{X=-58.25mm Y=121mm Z=0.4mm} ChamferEdgeEnd{X=-58.25mm Y=121mm Z=-0.4mm} ChamferEdgeMid{X=-58.25mm Y=121mm Z=0mm} ChamferEdgeMidTangent(0, 0, -1)}})
  Substrate.chamfer(Edges=Substrate.edge(at (48, 121, 0)) LeftDistance=6.25mm RightDistance=48mm ChamferType="Left Distance-Right Distance" ChamferAdditionalGeometryInfo{ChamferEdgeGeometryInfo{ChamferEdgeID=1343 ChamferEdgeSense ChamferEdgeStart{X=48mm Y=121mm Z=0.4mm} ChamferEdgeEnd{X=48mm Y=121mm Z=-0.4mm} ChamferEdgeMid{X=48mm Y=121mm Z=0mm} ChamferEdgeMidTangent(0, 0, -1)}})
  Fintenna [polyester] = imported_body(C:\Users\Garrett W\Documents\[A3-FIN] fintenna_assembly\[A3-FIN] fintenna_assembly - Fintenna.step)
  Fintenna.rotate(axis=Z, angle=90deg)
  Fintenna.rotate(axis=Y, angle=-90deg)
  Fintenna.move(-62.5mm, 73mm, -2.38125mm)
  Box14 = box(corner=(-58.25mm, $Radius, 0.4mm), size=(106.25mm, -16mm, -0.8mm))
  Substrate.unite(Box14)
  FinFoot1 [aluminum, non-model] = imported_body(C:\Users\Garrett W\Documents\[A3-FIN] fintenna_assembly\[A3-FIN] fintenna_assembly - Part 1.step)
  FinFoot [aluminum, non-model] = imported_body(C:\Users\Garrett W\Documents\[A3-FIN] fintenna_assembly\[A3-FIN] fintenna_assembly - Part 2.step)
  FinFoot1.rotate(axis=Y, angle=-90deg)
  FinFoot1.rotate(axis=Z, angle=90deg)
  FinFoot1.move(-62.5mm, 70.46mm, 2.38125mm)
  FinFoot.rotate(axis=Y, angle=-90deg)
  FinFoot.rotate(axis=Z, angle=90deg)
  FinFoot.move(-62.5mm, 70.46mm, 7.16915mm)
  coordinate_system RelativeCS1 = origin=(-58.25mm, $Radius, 0.435mm) x=(1mm, 0mm, 0mm) y=(0mm, 1mm, 0mm)
  Ground [copper] = box(corner=(7mm, -16mm, 0mm), size=(97mm, (60+4) mm, -0.035mm)) in RelativeCS1
  Ground.chamfer(Edges=Ground.edge(at (-51.25, 121, 0.4175)) LeftDistance=48mm RightDistance=50mm ChamferType="Left Distance-Right Distance" ChamferAdditionalGeometryInfo{ChamferEdgeGeometryInfo{ChamferEdgeID=6199 ChamferEdgeSense ChamferEdgeStart{X=-51.25mm Y=121mm Z=0.435mm} ChamferEdgeEnd{X=-51.25mm Y=121mm Z=0.4mm} ChamferEdgeMid{X=-51.25mm Y=121mm Z=0.4175mm} ChamferEdgeMidTangent(0, 0, -1)}})
  Ground.chamfer(Edges=Ground.edge(at (45.75, 121, 0.4175)) LeftDistance="(.25*25) mm" RightDistance=48mm ChamferType="Left Distance-Right Distance" ChamferAdditionalGeometryInfo{ChamferEdgeGeometryInfo{ChamferEdgeID=6200 ChamferEdgeSense ChamferEdgeStart{X=45.75mm Y=121mm Z=0.435mm} ChamferEdgeEnd{X=45.75mm Y=121mm Z=0.4mm} ChamferEdgeMid{X=45.75mm Y=121mm Z=0.4175mm} ChamferEdgeMidTangent(0, 0, -1)}})
  Slot = box(corner=($FeedX, $FeedY, 0mm), size=($RadLen, $RadWidth, -0.035mm)) in RelativeCS1
  Substrate.move_faces(MoveAlongNormalFlag=true OffsetDistance=15mm FacesToMove=Substrate.face(at (44.875, 97, 0), at (48, 65, 0))) in RelativeCS1  # suppressed
  Ground.move_faces(MoveAlongNormalFlag=true OffsetDistance=15mm FacesToMove=Ground.face(at (45.75, 65, 0.4175), at (42.625, 97, 0.4175))) in RelativeCS1  # suppressed
  coordinate_system LeftAngleRotate = origin=($FeedX, $FeedY, -0.035mm) x=(1mm, 0mm, 0mm) y=(0mm, 1mm, 0mm) in RelativeCS1
  coordinate_system RightAngleRotate = origin=($FeedX+$LineWidth, $FeedY, 0mm) x=(1mm, 0mm, 0mm) y=(0mm, 1mm, 0mm) in RelativeCS1
  Slot.rotate(axis=Z, angle=$angle) in LeftAngleRotate
  Fuselage [CF - Carbon fiber] = imported_body()
  Ground.subtract(Slot)
  FeedLine [copper] = box(corner=($FeedX-$FeedOffset+$RadLen, -16mm, -0.835mm), size=(-$LineWidth, 16mm+$FeedY+22.5mm, -0.035mm)) in RelativeCS1
  Rectangle1 = rectangle(corner=($FeedX-$LineWidth-$FeedOffset+$RadLen, -16mm, 0mm), z_size=-0.87mm, x_size=$LineWidth) in RelativeCS1
  FeedLine_1 = FeedLine.copy()
  Fintenna.subtract(FeedLine_1)
  FinFoot_2 = FinFoot.copy()
  FinFoot1_2 = FinFoot1.copy()
  Fuselage.subtract(FinFoot_2, FinFoot1_2)
  Slot1 = box(corner=($FeedX+$Radlen+12mm, $FeedY, 0mm), size=($RadLen, $RadWidth, -0.035mm)) in RelativeCS1
  coordinate_system LeftAngleRotate1 = origin=($FeedX, $FeedY, -0.035mm) x=(1mm, 0mm, 0mm) y=(0mm, 1mm, 0mm) in RelativeCS1
  Ground.subtract(Slot1)
  Ground_1 = Ground.copy()
  Fintenna.subtract(Ground_1)
  Substrate_1 = Substrate.copy()
  Fintenna.subtract(Substrate_1)
  Ground.move_faces(MoveAlongNormalFlag=true OffsetDistance=-3mm FacesToMove=Ground.face(at (19.125, 121, 0.4175))) in RelativeCS1
  group Fintenna1 = Fintenna
  group Part2 = FinFoot1
  group Part3 = FinFoot
boundaries and excitations:
  Rad1: Radiation Objects=Box13
  1: Lumped Port Objects=Rectangle1 LumpedPortType=Modal Modes{Mode1{IntLine{(-2.16, 57, 0.435) -> (-2.16, 57, -0.435)} CharImp=Zpi}} Impedance=50ohm
mesh:
  initial mesh: GlobalSurfApproximation{CurvedSurfaceApproxChoice=UseSlider SliderMeshSettings=1} GlobalCurvilinear{Apply} MeshMethod=AnsoftClassic DynamicSurfaceResolution
setups:
  Setup1: HfssDriven Frequency=1.575GHz MaxDeltaS=0.02 MaximumPasses=8 MinimumPasses=1 MinimumConvergedPasses=1 PercentRefinement=30 BasisOrder=1 PortAccuracy=2 DrivenSolverType="Direct Solver" InfiniteSphereSetup=69
    sweep Sweep: 1000MHz to 2000MHz, 120 points; disabled Type=Interpolating SaveFields InterpTolerance=0.5 InterpMaxSolns=50 PassivityErrorTolerance=0.0001
    sweep NarrorDiscrete: 1.5GHz to 1.6GHz, 200 points; disabled Type=Discrete SaveFields
    sweep QuickWideSweep: 0.5GHz to 10GHz, 401 points; disabled Type=Interpolating SaveFields InterpTolerance=0.5 InterpMaxSolns=250 PassivityErrorTolerance=0.0001
    sweep QuickNarrowSweep: 1GHz to 2GHz, 80 points; Type=Interpolating InterpTolerance=0.5 InterpMaxSolns=250 PassivityErrorTolerance=0.0001
source amplitudes:
  1:1: 1W 0deg
optimetrics:
  OptimizationSetup1: Optimization disabled Optimizer="DX AMO" AnalysisStopOptions{StopForNumIteration MaxNumIteration=625 MinNumIteration=10} CostFuncNormType=L2 Acceptable_Cost=0 Noise=0.0001 UpdateDesignWhenDone
    vary $FeedOffset: Min=0mm Max=15mm MinStep=0.05mm MaxStep=0.5mm MinFocus=2.5mm MaxFocus=7.5mm start=0mm
    goal dB(St(1,1)) Minimize 0 weight 1 on Setup1 : LastAdaptive at Freq 1.575GHz
radiation setups:
  Infinite Sphere1: Infinite Sphere Theta=0deg..180deg step 2deg Phi=-180deg..180deg step 2deg
reports:
  GainRHCP: dB(GainRHCP) vs Phi, Theta on Setup1 : LastAdaptive, Infinite Sphere1 [Freq=1.575GHz]
  GainRHCP_Fringe: dB(RealizedGainRHCP) vs Phi, Theta on Setup1 : LastAdaptive, Infinite Sphere1 [Freq=1.575GHz]
  Gain Plot3: dB(GainRHCP) vs Phi on Setup1 : LastAdaptive, Infinite Sphere1 [Theta=0deg,10deg,20deg,30deg,40deg,50deg,60deg,70deg,80deg,90deg,100deg,110deg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 Freq=1.575GHz $FeedOffset=14.1287mm]
  Antenna Params Plot1: TotalEfficiency vs Freq on Setup1 : LastAdaptive [$FeedOffset=5.03041mm]
  Axial Ratio Plot: mag(AxialRatioValue) vs Phi, Theta on Setup1 : LastAdaptive, Infinite Sphere1 [Freq=1.575GHz]
  GainLHCP: dB(GainLHCP) vs Phi, Theta on Setup1 : LastAdaptive, Infinite Sphere1 [Freq=1.575GHz]
  GainTotal: dB(GainTotal) vs Phi, Theta on Setup1 : LastAdaptive, Infinite Sphere1 [Freq=1.575GHz]
  Antenna Params Plot2: TotalEfficiency vs Freq on Setup1 : LastAdaptive; markers m1 at 1.575GHz
  Terminal S Parameter Plot1: dB(St(1,1)) vs Freq on Setup1 : QuickNarrowSweep
  Terminal S Parameter Chart1: St(1,1) on Setup1 : QuickNarrowSweep [Freq=all]; markers m1 at 1.6835443GHz

design HFSSDesign2 (HFSS, HFSS Terminal Network, model units mm)
geometry:
  TopGround = box(corner=(-20mm, $Radius, 0.8mm), size=(60mm, $PlaneWidth, 0.035mm))
  TopGround.chamfer(Edges=TopGround.edge(at (-20, 81, 0.8175)) LeftDistance=55deg RightDistance=$PlaneWidth ChamferType="Right Distance-Angle" ChamferAdditionalGeometryInfo{ChamferEdgeGeometryInfo{ChamferEdgeID=2238 ChamferEdgeSense ChamferEdgeStart{X=-30mm Y=81mm Z=0.8mm} ChamferEdgeEnd{X=-30mm Y=81mm Z=0.835mm} ChamferEdgeMid{X=-30mm Y=81mm Z=0.8175mm} ChamferEdgeMidTangent(0, 0, 1)}})  # suppressed
  TopGround.chamfer(Edges=TopGround.edge(at (40, 81, 0.8175)) LeftDistance=$PlaneWidth RightDistance=10deg ChamferType="Left Distance-Angle" ChamferAdditionalGeometryInfo{ChamferEdgeGeometryInfo{ChamferEdgeID=2239 ChamferEdgeSense ChamferEdgeStart{X=720mm Y=81mm Z=0.8mm} ChamferEdgeEnd{X=720mm Y=81mm Z=0.835mm} ChamferEdgeMid{X=720mm Y=81mm Z=0.8175mm} ChamferEdgeMidTangent(0, 0, 1)}})  # suppressed
  coordinate_system RelativeCS1 = origin=(-20mm, $Radius+$PlaneWidth, 0.8mm) x=(1mm, 0mm, 0mm) y=(0mm, 1mm, 0mm)
  StripCutTool = box(corner=($FeedGap-0.6mm, 8mm-$PlaneWidth, 0mm), size=(2.4mm, -10mm, 0.035mm)) in RelativeCS1
  TopGround.subtract(StripCutTool)
  TopGround.move_faces(MoveAlongNormalFlag=true OffsetDistance="(12+4) mm" FacesToMove=TopGround.face(at (-12.925, 73, 0.8175), at (18.275, 73, 0.8175)))
  ViaHole = cylinder(axis=Z, base_centre=($FeedGap-1.25mm, -1mm, -0.835mm), radius=0.25mm, height=1.67mm, segments=8) in RelativeCS1
  ViaHole.duplicate_along_line(step=(0mm, -1.5mm, 0mm), total=16, attached) in RelativeCS1
  ViaHole.duplicate_along_line(step=(3.7mm, 0mm, 0mm), total=2, attached) in RelativeCS1
  ViaHole_1 = ViaHole.copy()
  TopGround.subtract(ViaHole)
  TopGround_2 = TopGround.copy()
  TopGround.move(0mm, -3mm, 0mm) in RelativeCS1
  TopGround.delete()
  RadElement = box(corner=(0mm, $StubLen, 0mm), size=($RadLen, 1mm, 0.035mm)) in RelativeCS1
  Box16 = box(corner=($FeedGap, $StubLen, 0mm), size=(1.2mm, -($StubLen+$PlaneWidth+8.4mm), 0.035mm)) in RelativeCS1
  Box15 = box(corner=(0mm, $StubLen, 0mm), size=((1-.7) mm, -($StubLen), 0.035mm)) in RelativeCS1
  RadElement.unite(Box16, Box15)
  RadElement.chamfer(Edges=RadElement.edge(at (-19.7, 103, 0.8175)) LeftDistance=$Chamfer-0.2mm RightDistance=$Chamfer-0.2mm ChamferType=Symmetric ChamferAdditionalGeometryInfo{ChamferEdgeGeometryInfo{ChamferEdgeID=10509 ChamferEdgeSense ChamferEdgeStart{X=-19.7mm Y=103mm Z=0.8mm} ChamferEdgeEnd{X=-19.7mm Y=103mm Z=0.835mm} ChamferEdgeMid{X=-19.7mm Y=103mm Z=0.8175mm} ChamferEdgeMidTangent(0, 0, 1)}})
  RadElement.chamfer(Edges=RadElement.edge(at (-20, 104, 0.8175)) LeftDistance=$Chamfer+0.6mm RightDistance=$Chamfer+0.6mm ChamferType=Symmetric ChamferAdditionalGeometryInfo{ChamferEdgeGeometryInfo{ChamferEdgeID=1937 ChamferEdgeSense ChamferEdgeStart{X=-20mm Y=104mm Z=0.8mm} ChamferEdgeEnd{X=-20mm Y=104mm Z=0.835mm} ChamferEdgeMid{X=-20mm Y=104mm Z=0.8175mm} ChamferEdgeMidTangent(0, 0, 1)}})
  RadElement.move_faces(MoveAlongNormalFlag=true OffsetDistance=7.6mm FacesToMove=RadElement.face(at (-4.65, 64.6, 0.8175)))
  RadElement_2 = RadElement.copy()
  RadElement.move(0mm, -3mm, 0mm) in RelativeCS1
  RadElement.delete()
  Box13 [air] = box(corner=(-250mm, 200mm, 100mm), size=(500mm, -300mm, -200mm))
  BottomGround = box(corner=(-20mm, $Radius, 0.1mm), size=(60mm, $PlaneWidth, -0.035mm))
  BottomGround.move_faces(MoveAlongNormalFlag=true OffsetDistance="(12+4) mm" FacesToMove=BottomGround.face(-y))
  BottomGround.subtract(ViaHole_1)
  BottomGround_2 = BottomGround.copy()
  BottomGround.move(0mm, -3mm, 0mm) in RelativeCS1
  BottomGround.delete()
  Vias = cylinder(axis=Z, base_centre=($FeedGap-1.25mm, -1mm, -0.735mm), radius=0.25mm, height=0.77mm, segments=8) in RelativeCS1
  Vias.duplicate_along_line(step=(0mm, -1.5mm, 0mm), total=16, attached) in RelativeCS1
  Vias.duplicate_along_line(step=(3.7mm, 0mm, 0mm), total=2, attached) in RelativeCS1
  Vias1 = cylinder(axis=Z, base_centre=($FeedGap-1.25mm, -1mm, -1.635mm), radius=0.215mm, height=1.67mm, segments=8) in RelativeCS1
  Vias1.duplicate_along_line(step=(0mm, -1.5mm, 0mm), total=16, attached) in RelativeCS1
  Vias1.duplicate_along_line(step=(3.7mm, 0mm, 0mm), total=2, attached) in RelativeCS1
  Vias.subtract(Vias1)
  Vias_2 = Vias.copy()
  Vias.move(0mm, -3mm, 0mm) in RelativeCS1
  Vias.delete()
  Substrate [FR4_epoxy High Dielectric] = box(corner=(48mm, $Radius, 0.8mm), size=((-4.25*25) mm, 48mm, -0.7mm))
  Substrate.chamfer(Edges=Substrate.edge(at (-58.25, 121, 0.45)) LeftDistance=48mm RightDistance="(2.25*25) mm" ChamferType="Left Distance-Right Distance" ChamferAdditionalGeometryInfo{ChamferEdgeGeometryInfo{ChamferEdgeID=6737 ChamferEdgeSense ChamferEdgeStart{X=-58.25mm Y=121mm Z=0.8mm} ChamferEdgeEnd{X=-58.25mm Y=121mm Z=0.1mm} ChamferEdgeMid{X=-58.25mm Y=121mm Z=0.45mm} ChamferEdgeMidTangent(0, 0, -1)}})
  Substrate.chamfer(Edges=Substrate.edge(at (48, 121, 0.45)) LeftDistance=6.25mm RightDistance=48mm ChamferType="Left Distance-Right Distance" ChamferAdditionalGeometryInfo{ChamferEdgeGeometryInfo{ChamferEdgeID=6738 ChamferEdgeSense ChamferEdgeStart{X=48mm Y=121mm Z=0.8mm} ChamferEdgeEnd{X=48mm Y=121mm Z=0.1mm} ChamferEdgeMid{X=48mm Y=121mm Z=0.45mm} ChamferEdgeMidTangent(0, 0, -1)}})
  Box14 = box(corner=(-58.25mm, 73mm, 0.8mm), size=(106.25mm, -16mm, -0.7mm))
  Substrate.unite(Box14)
  Substrate_2 = Substrate.copy()
  Substrate.move(0mm, -3mm, 0mm) in RelativeCS1
  Fuselage [CF - Carbon fiber] = cylinder(axis=X, base_centre=(-250mm, 0mm, 0mm), radius=73mm, height=500mm, segments=20)
  Cylinder3 = cylinder(axis=X, base_centre=(300mm, 0mm, 0mm), radius=70.6mm, height=-600mm, segments=20)
  Fuselage.subtract(Cylinder3)
  BandCutTool = cylinder(axis=X, base_centre=($BandSpacing/2-5mm, 0mm, 0mm), radius=$Radius, height=3mm, segments=20)
  BandCutTool.duplicate_along_line(step=(-$BandSpacing, 0mm, 0mm), total=2, attached)
  Fuselage.subtract(BandCutTool)  # suppressed
  Fuselage.move_faces(MoveAlongNormalFlag=true OffsetDistance=-75mm FacesToMove=Fuselage.face(at (250, 0, 0), at (-250, 0, 0))) in RelativeCS1
  Fins [polyester] = imported_body(C:\Users\Garrett\Downloads\Fintenna - Fins.step) in RelativeCS1
  Fins.rotate(axis=Z, angle=90deg) in RelativeCS1
  Fins.rotate(axis=Y, angle=-90deg) in RelativeCS1
  Fins.move(-42.5mm, -8mm, -2.75mm) in RelativeCS1
  Fins_1 = Fins.copy()
  Fuselage.subtract(BottomGround_2, Fins_1, RadElement_2, Substrate_2, TopGround_2, Vias_2)
  FintennaPost [aluminum] = imported_body(C:\Users\Garrett\Downloads\finntenna post - Fintenna Post.step) in RelativeCS1
  FintennaPost.rotate(axis=Y, angle=-90deg) in RelativeCS1
  FintennaPost.move(24.28mm, 52.0625mm, 0mm) in RelativeCS1
  FintennaPost.move(-9.63mm, -73.5245mm, -2.75mm) in RelativeCS1
  Ground [copper] = box(corner=(7mm, -16mm, 0mm), size=(97mm, (60+4) mm, -0.035mm))
  Ground.chamfer(Edges=Ground.edge(at (7, 48, -0.0175)) LeftDistance=48mm RightDistance=50mm ChamferType="Left Distance-Right Distance" ChamferAdditionalGeometryInfo{ChamferEdgeGeometryInfo{ChamferEdgeID=66449 ChamferEdgeSense ChamferEdgeStart{X=7mm Y=48mm Z=0mm} ChamferEdgeEnd{X=7mm Y=48mm Z=-0.035mm} ChamferEdgeMid{X=7mm Y=48mm Z=-0.0175mm} ChamferEdgeMidTangent(0, 0, -1)}})
  Ground.chamfer(Edges=Ground.edge(at (104, 48, -0.0175)) LeftDistance="(.25*25) mm" RightDistance=48mm ChamferType="Left Distance-Right Distance" ChamferAdditionalGeometryInfo{ChamferEdgeGeometryInfo{ChamferEdgeID=66450 ChamferEdgeSense ChamferEdgeStart{X=104mm Y=48mm Z=0mm} ChamferEdgeEnd{X=104mm Y=48mm Z=-0.035mm} ChamferEdgeMid{X=104mm Y=48mm Z=-0.0175mm} ChamferEdgeMidTangent(0, 0, -1)}})
  Ground.move_faces(MoveAlongNormalFlag=true OffsetDistance=15mm FacesToMove=Ground.face(at (104, -8, -0.0175), at (100.875, 24, -0.0175)))  # suppressed
  coordinate_system LeftAngleRotate = origin=($FeedX, $FeedY, -0.035mm) x=(1mm, 0mm, 0mm) y=(0mm, 1mm, 0mm)
  Slot = box(corner=($FeedX, $FeedY, 0mm), size=($RadLen, $RadWidth, -0.035mm))
  Slot.rotate(axis=Z, angle=$angle) in LeftAngleRotate
  Ground.subtract(Slot)
  Slot1 = box(corner=($FeedX+$Radlen+7mm, $FeedY, 0mm), size=($RadLen, $RadWidth, -0.035mm))
  Ground.subtract(Slot1)
  Ground.move_faces(MoveAlongNormalFlag=true OffsetDistance=-3mm FacesToMove=Ground.face(at (77.375, 48, -0.0175)))
  FeedLine [copper] = box(corner=($FeedX-$FeedOffset+$RadLen, -16mm, -0.835mm), size=(-$LineWidth, 16mm+$FeedY+22.5mm, -0.035mm))
  [Ground, FeedLine].move(-59.5mm, 70mm, 0.835mm)
  FeedLine_1 = FeedLine.copy()
  Ground_1 = Ground.copy()
  Substrate_3 = Substrate.copy()
  Fins.subtract(FeedLine_1, Ground_1, Substrate_3)
  Rectangle1 = rectangle(corner=($FeedX-$LineWidth-$FeedOffset+$RadLen, -16mm, 0mm), z_size=-0.87mm, x_size=$LineWidth)
  Rectangle1.move(-59mm, 70mm, 0.835mm)
  Bolt1 [steel_stainless] = cylinder(axis=Z, base_centre=(10mm, 160mm, 0mm), radius=2.019mm, height=25mm)
  Bolt2 [steel_stainless] = cylinder(axis=Z, base_centre=(10mm, 160mm, 0mm), radius=2.019mm, height=25mm)
  Bolt3 [steel_stainless] = cylinder(axis=Z, base_centre=(10mm, 160mm, 0mm), radius=2.019mm, height=25mm)
  Bolt3.move(22.75mm, (-98.4427-2.0193) mm, -6mm)
  Bolt2.move(-9.3175mm, (-98.4427-2.0193) mm, -6mm)
  Bolt1.move(-53.45mm, (-98.4427-2.0193) mm, -6mm)
  Bolt1_1 = Bolt1.copy()
  Bolt2_1 = Bolt2.copy()
  Bolt3_1 = Bolt3.copy()
  Ground.subtract(Bolt1_1, Bolt2_1, Bolt3_1)
  Bolt1_2 = Bolt1.copy()
  Bolt2_2 = Bolt2.copy()
  Bolt3_2 = Bolt3.copy()
  Substrate.subtract(Bolt1_2, Bolt2_2, Bolt3_2)
  FintennaPost.move(0mm, 0mm, 20.75mm)
  Ground.chamfer(Edges=Ground.edge(at (-5.625, 115, 0.8175)) LeftDistance=1mm RightDistance=5mm ChamferType="Left Distance-Right Distance" ChamferAdditionalGeometryInfo{ChamferEdgeGeometryInfo{ChamferEdgeID=66462 ChamferEdgeSense ChamferEdgeStart{X=-5.625mm Y=115mm Z=0.8mm} ChamferEdgeEnd{X=-5.625mm Y=115mm Z=0.835mm} ChamferEdgeMid{X=-5.625mm Y=115mm Z=0.8175mm} ChamferEdgeMidTangent(0, 0, 1)}})
  [Box13, Substrate, Fuselage, Fins, FintennaPost, Ground, FeedLine, Rectangle1, Bolt1, Bolt2, Bolt3].rotate(axis=Y, angle=90deg)
  group Fins1 = Fins
  group FintennaPost1 = FintennaPost
boundaries and excitations:
  Rad1: Radiation Objects=Box13
  1: Lumped Port Objects=Rectangle1 LumpedPortType=Modal Modes{Mode1{IntLine{(0.835, 54, 2.91) -> (-0.035, 54, 2.91)} CharImp=Zpi}} Impedance=50ohm
mesh:
  initial mesh: GlobalSurfApproximation{CurvedSurfaceApproxChoice=UseSlider SliderMeshSettings=4} GlobalCurvilinear{Apply} MeshMethod=AnsoftTAU
setups:
  Setup1: HfssDriven MultipleAdaptiveFreqsSetup{AdaptAt{Frequency=1.559GHz Delta=0.01} AdaptAt{Frequency=1.575GHz Delta=0.01} AdaptAt{Frequency=1.61GHz Delta=0.01}} MaximumPasses=16 MinimumPasses=1 MinimumConvergedPasses=1 PercentRefinement=30 BasisOrder=1 PortAccuracy=2 DrivenSolverType="Direct Solver" InfiniteSphereSetup=4
    sweep Sweep: 1400MHz to 1800MHz, 400 points; Type=Interpolating SaveFields InterpTolerance=0.5 InterpMaxSolns=250 PassivityErrorTolerance=0.0001
source amplitudes:
  1:1: 1V 0deg
radiation setups:
  Infinite Sphere1: Infinite Sphere Theta=-180deg..180deg step 2deg Phi=-180deg..180deg step 2deg
reports:
  GainRHCP: dB(GainRHCP) vs Phi, Theta on Setup1 : LastAdaptive, Infinite Sphere1
  RealizedGain3D: dB(RealizedGainRHCP) vs Phi, Theta on Setup1 : LastAdaptive, Infinite Sphere1 [Freq=1.575GHz]
  X-Y Plane: dB(RealizedGainRHCP) vs Phi on Setup1 : LastAdaptive, Infinite Sphere1 [Theta=90deg Freq=1.575GHz]
  Antenna Params Plot1: TotalEfficiency vs Freq on Setup1 : LastAdaptive; markers m1 at 1.575GHz
  Axial Ratio Plot: mag(AxialRatioValue) vs Phi, Theta on Setup1 : LastAdaptive, Infinite Sphere1 [Freq=1.575GHz]
  GainLHCP: dB(GainLHCP) vs Phi, Theta on Setup1 : LastAdaptive, Infinite Sphere1 [Freq=1.575GHz]
  GainTotal: dB(GainTotal) vs Phi, Theta on Setup1 : LastAdaptive, Infinite Sphere1 [Freq=1.575GHz]
  Terminal S Parameter Plot1: dB(St(1,1)) vs Freq on Setup1 : Sweep; markers Resonant Frequency at 1.6205514GHz, Center of Band at 1.5754386GHz, Bottom of Band at 1.5593985GHz, Top of Band at 1.6115288GHz
  Terminal S Parameter Chart1: St(1,1) on Setup1 : Sweep [Freq=all]; markers m1 at 1.6835443GHz, m2 at 1.5801342GHz
  Terminal VSWR Plot1: VSWRt(1) vs Freq on Setup1 : Sweep
  Y-Z Plane: dB(RealizedGainRHCP) vs Theta on Setup1 : LastAdaptive, Infinite Sphere1 [Phi=180deg Freq=1.575GHz]
  X-Z Plane: dB(RealizedGainRHCP) vs Theta on Setup1 : LastAdaptive, Infinite Sphere1 [Phi=90deg Freq=1.575GHz]
  Realized Gain Table1: dB(RealizedGainRHCP) vs Theta on Setup1 : LastAdaptive, Infinite Sphere1 [Phi=all Freq=1.575GHz]

# Ansys Electronics Desktop project, version 2025.2
project variables:
  $Radius = 73mm
  $StubLen = 22mm
  $RadLen = 53mm
  $FeedGap = 14.75mm
  $PlaneWidth = 8mm
  $SizeMult = 0.94864648
  $Chamfer = 8mm
  $BandSpacing = (5*25.4) mm
materials:
  vacuum: permittivity=1
  copper: permeability=0.999991 conductivity=58000000
  air: permittivity=1.0006 permeability=1.0000004
  graphite: conductivity=70000
  FR4_epoxy: permittivity=4.4 dielectric_loss_tangent=0.02
  cast_iron: permeability=60 conductivity=1500000
  CF - Carbon fiber: conductivity=252.337
  aluminum: permeability=1.000021 conductivity=38000000
  cyanate_ester: permittivity=3.8
  FR4_epoxy High Dielectric: permittivity=4.5 dielectric_loss_tangent=0.02
  modified_epoxy: permittivity=4.2 dielectric_loss_tangent=0.02
  polyester: permittivity=3.2 dielectric_loss_tangent=0.003

design HFSSDesign3 (HFSS, HFSS Terminal Network, model units mm)
geometry:
  TopGround [copper] = box(corner=(-20mm, $Radius, 0.8mm), size=(60mm, $PlaneWidth, 0.035mm))
  TopGround.chamfer(Edges=TopGround.edge(at (-20, 81, 0.8175)) LeftDistance=55deg RightDistance=$PlaneWidth ChamferType="Right Distance-Angle" ChamferAdditionalGeometryInfo{ChamferEdgeGeometryInfo{ChamferEdgeID=2238 ChamferEdgeSense ChamferEdgeStart{X=-30mm Y=81mm Z=0.8mm} ChamferEdgeEnd{X=-30mm Y=81mm Z=0.835mm} ChamferEdgeMid{X=-30mm Y=81mm Z=0.8175mm} ChamferEdgeMidTangent(0, 0, 1)}})  # suppressed
  TopGround.chamfer(Edges=TopGround.edge(at (40, 81, 0.8175)) LeftDistance=$PlaneWidth RightDistance=10deg ChamferType="Left Distance-Angle" ChamferAdditionalGeometryInfo{ChamferEdgeGeometryInfo{ChamferEdgeID=2239 ChamferEdgeSense ChamferEdgeStart{X=720mm Y=81mm Z=0.8mm} ChamferEdgeEnd{X=720mm Y=81mm Z=0.835mm} ChamferEdgeMid{X=720mm Y=81mm Z=0.8175mm} ChamferEdgeMidTangent(0, 0, 1)}})  # suppressed
  coordinate_system RelativeCS1 = origin=(-20mm, $Radius+$PlaneWidth, 0.8mm) x=(1mm, 0mm, 0mm) y=(0mm, 1mm, 0mm)
  StripCutTool = box(corner=($FeedGap-0.6mm, 8mm-$PlaneWidth, 0mm), size=(2.4mm, -10mm, 0.035mm)) in RelativeCS1
  TopGround.subtract(StripCutTool)
  RadElement [copper] = box(corner=(0mm, $StubLen, 0mm), size=($RadLen, 1mm, 0.035mm)) in RelativeCS1
  Box16 = box(corner=($FeedGap, $StubLen, 0mm), size=(1.2mm, -($StubLen+$PlaneWidth+8.4mm), 0.035mm)) in RelativeCS1
  Box15 = box(corner=(0mm, $StubLen, 0mm), size=((1-.7) mm, -($StubLen), 0.035mm)) in RelativeCS1
  RadElement.unite(Box16, Box15)
  RadElement.chamfer(Edges=RadElement.edge(at (-19.7, 103, 0.8175)) LeftDistance=$Chamfer-0.2mm RightDistance=$Chamfer-0.2mm ChamferType=Symmetric ChamferAdditionalGeometryInfo{ChamferEdgeGeometryInfo{ChamferEdgeID=182 ChamferEdgeSense ChamferEdgeStart{X=-19.7mm Y=103mm Z=0.8mm} ChamferEdgeEnd{X=-19.7mm Y=103mm Z=0.835mm} ChamferEdgeMid{X=-19.7mm Y=103mm Z=0.8175mm} ChamferEdgeMidTangent(0, 0, 1)}})
  RadElement.chamfer(Edges=RadElement.edge(at (-20, 104, 0.8175)) LeftDistance=$Chamfer+0.6mm RightDistance=$Chamfer+0.6mm ChamferType=Symmetric ChamferAdditionalGeometryInfo{ChamferEdgeGeometryInfo{ChamferEdgeID=125 ChamferEdgeSense ChamferEdgeStart{X=-20mm Y=104mm Z=0.8mm} ChamferEdgeEnd{X=-20mm Y=104mm Z=0.835mm} ChamferEdgeMid{X=-20mm Y=104mm Z=0.8175mm} ChamferEdgeMidTangent(0, 0, 1)}})
  Box13 [air] = box(corner=(-250mm, 200mm, 100mm), size=(500mm, -300mm, -200mm))
  BottomGround [copper] = box(corner=(-20mm, $Radius, 0.1mm), size=(60mm, $PlaneWidth, -0.035mm))
  ViaHole = cylinder(axis=Z, base_centre=($FeedGap-1.25mm, -1mm, -0.835mm), radius=0.25mm, height=1.67mm, segments=8) in RelativeCS1
  ViaHole.duplicate_along_line(step=(0mm, -1.5mm, 0mm), total=16, attached) in RelativeCS1
  ViaHole.duplicate_along_line(step=(3.7mm, 0mm, 0mm), total=2, attached) in RelativeCS1
  Vias [copper] = cylinder(axis=Z, base_centre=($FeedGap-1.25mm, -1mm, -0.735mm), radius=0.25mm, height=0.77mm, segments=8) in RelativeCS1
  Vias.duplicate_along_line(step=(0mm, -1.5mm, 0mm), total=16, attached) in RelativeCS1
  Vias.duplicate_along_line(step=(3.7mm, 0mm, 0mm), total=2, attached) in RelativeCS1
  Vias1 = cylinder(axis=Z, base_centre=($FeedGap-1.25mm, -1mm, -1.635mm), radius=0.215mm, height=1.67mm, segments=8) in RelativeCS1
  Vias1.duplicate_along_line(step=(0mm, -1.5mm, 0mm), total=16, attached) in RelativeCS1
  Vias1.duplicate_along_line(step=(3.7mm, 0mm, 0mm), total=2, attached) in RelativeCS1
  Vias.subtract(Vias1)
  Substrate [FR4_epoxy High Dielectric] = box(corner=(48mm, $Radius, 0.8mm), size=((-4.25*25) mm, 48mm, -0.7mm))
  Substrate.chamfer(Edges=Substrate.edge(at (-58.25, 121, 0.45)) LeftDistance=48mm RightDistance="(2.25*25) mm" ChamferType="Left Distance-Right Distance" ChamferAdditionalGeometryInfo{ChamferEdgeGeometryInfo{ChamferEdgeID=1439 ChamferEdgeSense ChamferEdgeStart{X=-58.25mm Y=121mm Z=0.8mm} ChamferEdgeEnd{X=-58.25mm Y=121mm Z=0.1mm} ChamferEdgeMid{X=-58.25mm Y=121mm Z=0.45mm} ChamferEdgeMidTangent(0, 0, -1)}})
  Substrate.chamfer(Edges=Substrate.edge(at (48, 121, 0.45)) LeftDistance=6.25mm RightDistance=48mm ChamferType="Left Distance-Right Distance" ChamferAdditionalGeometryInfo{ChamferEdgeGeometryInfo{ChamferEdgeID=1440 ChamferEdgeSense ChamferEdgeStart{X=48mm Y=121mm Z=0.8mm} ChamferEdgeEnd{X=48mm Y=121mm Z=0.1mm} ChamferEdgeMid{X=48mm Y=121mm Z=0.45mm} ChamferEdgeMidTangent(0, 0, -1)}})
  Box14 = box(corner=(-58.25mm, 73mm, 0.8mm), size=(106.25mm, -16mm, -0.7mm))
  Substrate.unite(Box14)
  TopGround.move_faces(MoveAlongNormalFlag=true OffsetDistance="(12+4) mm" FacesToMove=TopGround.face(at (-12.925, 73, 0.8175), at (18.275, 73, 0.8175)))
  BottomGround.move_faces(MoveAlongNormalFlag=true OffsetDistance="(12+4) mm" FacesToMove=BottomGround.face(at (10, 73, 0.0825)))
  RadElement.move_faces(MoveAlongNormalFlag=true OffsetDistance=7.6mm FacesToMove=RadElement.face(at (-4.65, 64.6, 0.8175)))
  ViaHole_1 = ViaHole.copy()
  BottomGround.subtract(ViaHole_1)
  ViaHole_2 = ViaHole.copy()
  Substrate.subtract(ViaHole_2)
  TopGround.subtract(ViaHole)
  Rectangle1 = rectangle(corner=($FeedGap, -($PlaneWidth+16mm), 0.035mm), z_size=-0.77mm, x_size=1.2mm) in RelativeCS1
  Fuselage [CF - Carbon fiber] = cylinder(axis=X, base_centre=(-250mm, 0mm, 0mm), radius=73mm, height=500mm, segments=20)
  Cylinder3 = cylinder(axis=X, base_centre=(300mm, 0mm, 0mm), radius=70.6mm, height=-600mm, segments=20)
  Fuselage.subtract(Cylinder3)
  BandCutTool = cylinder(axis=X, base_centre=($BandSpacing/2-5mm, 0mm, 0mm), radius=$Radius, height=3mm, segments=20)
  BandCutTool.duplicate_along_line(step=(-$BandSpacing, 0mm, 0mm), total=2, attached)
  Fuselage.subtract(BandCutTool)  # suppressed
  Fuselage.move_faces(MoveAlongNormalFlag=true OffsetDistance=-75mm FacesToMove=Fuselage.face(at (250, 0, 0), at (-250, 0, 0))) in RelativeCS1
  Fins [polyester] = imported_body(C:\Users\Garrett\Downloads\Fintenna - Fins.step) in RelativeCS1
  FinWasher [aluminum, non-model] = imported_body(C:\Users\Garrett\Downloads\Fintenna_washer - Fin Washer.step) in RelativeCS1
  FintennaPost [aluminum] = imported_body(C:\Users\Garrett\Downloads\finntenna post - Fintenna Post.step) in RelativeCS1
  Fins.rotate(axis=Z, angle=90deg) in RelativeCS1
  [Fins, FintennaPost].rotate(axis=Y, angle=-90deg) in RelativeCS1
  FinWasher.rotate(axis=Z, angle=90deg) in RelativeCS1
  FinWasher.rotate(axis=Y, angle=-90deg) in RelativeCS1
  Fins.move(-42.5mm, -8mm, -2.75mm) in RelativeCS1
  FintennaPost.move(24.28mm, 52.0625mm, 0mm) in RelativeCS1
  FintennaPost.move(-9.63mm, -73.5245mm, -2.75mm) in RelativeCS1
  FinWasher.move(65.2280802mm, -26.542mm, 2.026mm) in RelativeCS1
  BottomGround_2 = BottomGround.copy()
  Fins_1 = Fins.copy()
  RadElement_2 = RadElement.copy()
  Substrate_2 = Substrate.copy()
  TopGround_2 = TopGround.copy()
  Vias_2 = Vias.copy()
  Fuselage.subtract(BottomGround_2, Fins_1, RadElement_2, Substrate_2, TopGround_2, Vias_2)
  [Substrate, BottomGround, RadElement, TopGround, Vias].move(0mm, -3mm, 0mm) in RelativeCS1
  BottomGround_3 = BottomGround.copy()
  RadElement_3 = RadElement.copy()
  Substrate_3 = Substrate.copy()
  TopGround_3 = TopGround.copy()
  Vias_3 = Vias.copy()
  Fins.subtract(BottomGround_3, RadElement_3, Substrate_3, TopGround_3, Vias_3)
  Rectangle1.move(1.7763568e-15mm, -3mm, 0mm) in RelativeCS1
  [Fins, TopGround, RadElement, Box13, BottomGround, Vias, Substrate, Rectangle1, Fuselage, FinWasher, FintennaPost].rotate(axis=Y, angle=90deg) in RelativeCS1
  group Fins1 = Fins
  group FinWasher1 = FinWasher
  group FintennaPost1 = FintennaPost
boundaries and excitations:
  Rad1: Radiation Objects=Box13
  1: Lumped Port Objects=Rectangle1 LumpedPortType=Modal Modes{Mode1{IntLine{(-19.965, 54, -14.55) -> (-20.735, 54, -14.55)} CharImp=Zpi}} Impedance=50ohm
mesh:
  initial mesh: GlobalSurfApproximation{CurvedSurfaceApproxChoice=UseSlider SliderMeshSettings=3} GlobalCurvilinear{Apply} MeshMethod=AnsoftTAU DynamicSurfaceResolution
setups:
  Setup1: HfssDriven Frequency=915MHz MaxDeltaS=0.02 MaximumPasses=12 MinimumPasses=1 MinimumConvergedPasses=1 PercentRefinement=30 BasisOrder=1 PortAccuracy=2 DrivenSolverType="Direct Solver" InfiniteSphereSetup=1
    sweep Sweep: 800MHz to 1000MHz, 400 points; Type=Interpolating SaveFields InterpTolerance=0.5 InterpMaxSolns=250 PassivityErrorTolerance=0.0001
source amplitudes:
  1:1: 1V 0deg
radiation setups:
  Infinite Sphere1: Infinite Sphere Theta=-180deg..180deg step 2deg Phi=-180deg..180deg step 2deg
reports:
  Gain Plot1: dB(GainTotal) vs Phi, Theta on Setup1 : LastAdaptive, Infinite Sphere1 [Freq=0.915GHz]
  Terminal VSWR Plot1: VSWRt(1) vs Freq on Setup1 : Sweep; markers m1 at 0.91457286GHz
  Terminal S Parameter Plot1: dB(St(1,1)) vs Freq on Setup1 : Sweep; markers m1 at 0.91557789GHz, m2 at 0.87218045GHz, m3 at 0.94636591GHz
  Gain Plot3: dB(RealizedGainTotal) vs Phi on Setup1 : LastAdaptive, Infinite Sphere1 [Theta=90deg Freq=0.915GHz]; markers m1 at 0deg, m2 at 86deg, m3 at 180deg
  Realized Gain Plot1: dB(RealizedGainTotal) vs Phi, Theta on Setup1 : LastAdaptive, Infinite Sphere1 [Freq=0.915GHz]
  Gain Plot3_1: dB(RealizedGainTotal) vs Phi on Setup1 : LastAdaptive, Infinite Sphere1 [Theta=90deg Freq=0.915GHz]; markers m1 at 34deg, m2 at 90deg, m3 at 150deg
  Antenna Params Plot1: RadiationEfficiency vs Freq on Setup1 : LastAdaptive; markers m1 at 915MHz
  Terminal S Parameter Chart1: St(1,1) on Setup1 : Sweep [Freq=all]; markers m1 at 0.91557789GHz
  Gain Plot3_2: dB(RealizedGainTotal) vs Theta on Setup1 : LastAdaptive, Infinite Sphere1 [Phi=180deg Freq=0.915GHz]
  Gain Plot3_2_1: dB(RealizedGainTotal) vs Theta on Setup1 : LastAdaptive, Infinite Sphere1 [Phi=90deg Freq=0.915GHz]; markers m1 at -46deg
  Realized Gain Table1: dB(RealizedGainTotal) vs Theta on Setup1 : LastAdaptive, Infinite Sphere1 [Phi=all Freq=0.915GHz]

# Ansys Electronics Desktop project, version 2025.2
project variables:
  $Radius = 73mm
  $StubLen = 20mm
  $RadLen = 62mm  # optimise 54mm..60mm
  $FeedGap = 14.2mm  # optimise 7mm..15mm
  $PlaneWidth = 8mm
  $SizeMult = 0.94864648
  $Chamfer = 8mm
materials:
  vacuum: permittivity=1
  copper: permeability=0.999991 conductivity=58000000
  air: permittivity=1.0006 permeability=1.0000004
  graphite: conductivity=70000
  FR4_epoxy: permittivity=4.4 dielectric_loss_tangent=0.02
  cast_iron: permeability=60 conductivity=1500000
  CF - Carbon fiber: conductivity=252.337
  aluminum: permeability=1.000021 conductivity=38000000
  cyanate_ester: permittivity=3.8

design HFSSDesign3 (HFSS, HFSS Terminal Network, model units mm)
geometry:
  TopGround [copper] = box(corner=(-20mm, $Radius, 0.8mm), size=(60mm, $PlaneWidth, 0.035mm))
  TopGround.chamfer(Edges=TopGround.edge(at (-20, 81, 0.8175)) LeftDistance=55deg RightDistance=$PlaneWidth ChamferType="Right Distance-Angle" ChamferAdditionalGeometryInfo{ChamferEdgeGeometryInfo{ChamferEdgeID=2238 ChamferEdgeSense ChamferEdgeStart{X=-30mm Y=81mm Z=0.8mm} ChamferEdgeEnd{X=-30mm Y=81mm Z=0.835mm} ChamferEdgeMid{X=-30mm Y=81mm Z=0.8175mm} ChamferEdgeMidTangent(0, 0, 1)}})  # suppressed
  TopGround.chamfer(Edges=TopGround.edge(at (40, 81, 0.8175)) LeftDistance=$PlaneWidth RightDistance=10deg ChamferType="Left Distance-Angle" ChamferAdditionalGeometryInfo{ChamferEdgeGeometryInfo{ChamferEdgeID=2239 ChamferEdgeSense ChamferEdgeStart{X=720mm Y=81mm Z=0.8mm} ChamferEdgeEnd{X=720mm Y=81mm Z=0.835mm} ChamferEdgeMid{X=720mm Y=81mm Z=0.8175mm} ChamferEdgeMidTangent(0, 0, 1)}})  # suppressed
  coordinate_system RelativeCS1 = origin=(-20mm, $Radius+$PlaneWidth, 0.8mm) x=(1mm, 0mm, 0mm) y=(0mm, 1mm, 0mm)
  StripCutTool = box(corner=($FeedGap-0.6mm, 8mm-$PlaneWidth, 0mm), size=(2.7mm, -10mm, 0.035mm)) in RelativeCS1
  TopGround.subtract(StripCutTool)
  RadElement [copper] = box(corner=(0mm, $StubLen, 0mm), size=($RadLen, 1mm, 0.035mm)) in RelativeCS1
  Box16 = box(corner=($FeedGap, $StubLen, 0mm), size=(1.5mm, -($StubLen+$PlaneWidth+4.4mm), 0.035mm)) in RelativeCS1
  Box15 = box(corner=(0mm, $StubLen, 0mm), size=(1mm, -($StubLen), 0.035mm)) in RelativeCS1
  RadElement.unite(Box16, Box15)
  RadElement.chamfer(Edges=RadElement.edge(at (-19, 101, 0.8175)) LeftDistance=$Chamfer RightDistance=$Chamfer ChamferType=Symmetric ChamferAdditionalGeometryInfo{ChamferEdgeGeometryInfo{ChamferEdgeID=182 ChamferEdgeSense ChamferEdgeStart{X=-19mm Y=101mm Z=0.8mm} ChamferEdgeEnd{X=-19mm Y=101mm Z=0.835mm} ChamferEdgeMid{X=-19mm Y=101mm Z=0.8175mm} ChamferEdgeMidTangent(0, 0, 1)}})
  RadElement.chamfer(Edges=RadElement.edge(at (-20, 102, 0.8175)) LeftDistance=$Chamfer+0.6mm RightDistance=$Chamfer+0.6mm ChamferType=Symmetric ChamferAdditionalGeometryInfo{ChamferEdgeGeometryInfo{ChamferEdgeID=125 ChamferEdgeSense ChamferEdgeStart{X=-20mm Y=102mm Z=0.8mm} ChamferEdgeEnd{X=-20mm Y=102mm Z=0.835mm} ChamferEdgeMid{X=-20mm Y=102mm Z=0.8175mm} ChamferEdgeMidTangent(0, 0, 1)}})
  Box13 [air] = box(corner=(-200mm, 200mm, 100mm), size=(400mm, -300mm, -200mm))
  BottomGround [copper] = box(corner=(-20mm, $Radius, -0.8mm), size=(60mm, $PlaneWidth, -0.035mm))
  coordinate_system RelativeCS2 = origin=(-20mm, $Radius+$PlaneWidth, 0.8mm) x=(1mm, 0mm, 0mm) y=(0mm, 1mm, 0mm) in RelativeCS1
  ViaHole = cylinder(axis=Z, base_centre=($FeedGap-1.25mm, -1mm, -1.635mm), radius=0.25mm, height=1.67mm) in RelativeCS1
  ViaHole.duplicate_along_line(step=(0mm, -1.5mm, 0mm), total=13, attached) in RelativeCS1
  ViaHole.duplicate_along_line(step=(4mm, 0mm, 0mm), total=2, attached) in RelativeCS1
  Vias [copper] = cylinder(axis=Z, base_centre=($FeedGap-1.25mm, -1mm, -1.635mm), radius=0.25mm, height=1.67mm) in RelativeCS1
  Vias.duplicate_along_line(step=(0mm, -1.5mm, 0mm), total=13, attached) in RelativeCS1
  Vias.duplicate_along_line(step=(4mm, 0mm, 0mm), total=2, attached) in RelativeCS1
  Vias1 = cylinder(axis=Z, base_centre=($FeedGap-1.25mm, -1mm, -1.635mm), radius=0.215mm, height=1.67mm) in RelativeCS1
  Vias1.duplicate_along_line(step=(0mm, -1.5mm, 0mm), total=13, attached) in RelativeCS1
  Vias1.duplicate_along_line(step=(4mm, 0mm, 0mm), total=2, attached) in RelativeCS1
  Vias.subtract(Vias1)
  Substrate [FR4_epoxy] = box(corner=(48mm, $Radius, 0.8mm), size=((-4.25*25) mm, 48mm, -1.6mm))
  Substrate.chamfer(Edges=Substrate.edge(at (-58.25, 121, 0)) LeftDistance=48mm RightDistance="(2.25*25) mm" ChamferType="Left Distance-Right Distance" ChamferAdditionalGeometryInfo{ChamferEdgeGeometryInfo{ChamferEdgeID=1439 ChamferEdgeSense ChamferEdgeStart{X=-58.25mm Y=121mm Z=0.8mm} ChamferEdgeEnd{X=-58.25mm Y=121mm Z=-0.8mm} ChamferEdgeMid{X=-58.25mm Y=121mm Z=0mm} ChamferEdgeMidTangent(0, 0, -1)}})
  Substrate.chamfer(Edges=Substrate.edge(at (48, 121, 0)) LeftDistance=6.25mm RightDistance=48mm ChamferType="Left Distance-Right Distance" ChamferAdditionalGeometryInfo{ChamferEdgeGeometryInfo{ChamferEdgeID=1440 ChamferEdgeSense ChamferEdgeStart{X=48mm Y=121mm Z=0.8mm} ChamferEdgeEnd{X=48mm Y=121mm Z=-0.8mm} ChamferEdgeMid{X=48mm Y=121mm Z=0mm} ChamferEdgeMidTangent(0, 0, -1)}})
  Box14 = box(corner=(-58.25mm, 73mm, 0.8mm), size=(106.25mm, -12mm, -1.6mm))
  Substrate.unite(Box14)
  Fintenna [cyanate_ester] = imported_body(C:\Users\Garrett W\Documents\[A3-FIN] fintenna_assembly\[A3-FIN] fintenna_assembly - Fintenna.step)
  Fintenna.rotate(axis=Z, angle=90deg)
  Fintenna.rotate(axis=Y, angle=-90deg)
  Fintenna.move(-62.5mm, 73mm, -2.38125mm)
  AntennaCut = box(corner=(48mm, $Radius, 0.835mm), size=((-4.25*25) mm, 48mm, -1.67mm))
  AntennaCut.chamfer(Edges=AntennaCut.edge(at (-58.25, 121, 0)) LeftDistance=48mm RightDistance="(2.25*25) mm" ChamferType="Left Distance-Right Distance" ChamferAdditionalGeometryInfo{ChamferEdgeGeometryInfo{ChamferEdgeID=2427 ChamferEdgeSense ChamferEdgeStart{X=-58.25mm Y=121mm Z=0.835mm} ChamferEdgeEnd{X=-58.25mm Y=121mm Z=-0.835mm} ChamferEdgeMid{X=-58.25mm Y=121mm Z=0mm} ChamferEdgeMidTangent(0, 0, -1)}})
  AntennaCut.chamfer(Edges=AntennaCut.edge(at (48, 121, 0)) LeftDistance=6.25mm RightDistance=48mm ChamferType="Left Distance-Right Distance" ChamferAdditionalGeometryInfo{ChamferEdgeGeometryInfo{ChamferEdgeID=2428 ChamferEdgeSense ChamferEdgeStart{X=48mm Y=121mm Z=0.835mm} ChamferEdgeEnd{X=48mm Y=121mm Z=-0.835mm} ChamferEdgeMid{X=48mm Y=121mm Z=0mm} ChamferEdgeMidTangent(0, 0, -1)}})
  Box18 = box(corner=(-58.25mm, 73mm, 0.835mm), size=(106.25mm, -12.065mm, -1.67mm))
  AntennaCut.unite(Box18)
  Fintenna.subtract(AntennaCut)
  FinFoot1 [aluminum] = imported_body(C:\Users\Garrett W\Documents\[A3-FIN] fintenna_assembly\[A3-FIN] fintenna_assembly - Part 1.step)
  FinFoot1.rotate(axis=Y, angle=-90deg)
  FinFoot1.rotate(axis=Z, angle=90deg)
  FinFoot1.move(-62.5mm, 70.46mm, 2.38125mm)
  FinFoot [aluminum] = imported_body(C:\Users\Garrett W\Documents\[A3-FIN] fintenna_assembly\[A3-FIN] fintenna_assembly - Part 2.step)
  FinFoot.rotate(axis=Y, angle=-90deg)
  FinFoot.rotate(axis=Z, angle=90deg)
  FinFoot.move(-62.5mm, 70.46mm, 7.16915mm)
  TopGround.move_faces(MoveAlongNormalFlag=true OffsetDistance=12mm FacesToMove=TopGround.face(at (-13.2, 73, 0.8175), at (18.15, 73, 0.8175)))
  BottomGround.move_faces(MoveAlongNormalFlag=true OffsetDistance=12mm FacesToMove=BottomGround.face(-y))
  RadElement.move_faces(MoveAlongNormalFlag=true OffsetDistance=7.6mm FacesToMove=RadElement.face(at (-5.05, 68.6, 0.8175)))
  ViaHole_1 = ViaHole.copy()
  BottomGround.subtract(ViaHole_1)
  ViaHole_2 = ViaHole.copy()
  Substrate.subtract(ViaHole_2)
  TopGround.subtract(ViaHole)
  Rectangle1 = rectangle(corner=(-5.8mm, 61mm, 0.835mm), z_size=-1.67mm, x_size=1.5mm)
  Fuselage [CF - Carbon fiber] = cylinder(axis=X, base_centre=(-200mm, 0mm, 0mm), radius=73mm, height=400mm, segments=32)
  Cylinder3 = cylinder(axis=X, base_centre=(200mm, 0mm, 0mm), radius=70.6mm, height=-400mm)
  Fuselage.subtract(Cylinder3)
  Fintenna2 = imported_body(C:\Users\Garrett W\Documents\[A3-FIN] fintenna_assembly\[A3-FIN] fintenna_assembly - Fintenna.step)
  Fintenna2.rotate(axis=Z, angle=90deg)
  Fintenna2.rotate(axis=Y, angle=-90deg)
  Fintenna2.move(-62.5mm, 73mm, -2.38125mm)
  AntennaCut1 = box(corner=(48mm, $Radius, 0.835mm), size=((-4.25*25) mm, 48mm, -1.67mm))
  AntennaCut1.chamfer(Edges=AntennaCut1.edge(at (-58.25, 121, 0)) LeftDistance=48mm RightDistance="(2.25*25) mm" ChamferType="Left Distance-Right Distance" ChamferAdditionalGeometryInfo{ChamferEdgeGeometryInfo{ChamferEdgeID=7523 ChamferEdgeSense ChamferEdgeStart{X=-58.25mm Y=121mm Z=0.835mm} ChamferEdgeEnd{X=-58.25mm Y=121mm Z=-0.835mm} ChamferEdgeMid{X=-58.25mm Y=121mm Z=0mm} ChamferEdgeMidTangent(0, 0, -1)}})
  AntennaCut1.chamfer(Edges=AntennaCut1.edge(at (48, 121, 0)) LeftDistance=6.25mm RightDistance=48mm ChamferType="Left Distance-Right Distance" ChamferAdditionalGeometryInfo{ChamferEdgeGeometryInfo{ChamferEdgeID=7524 ChamferEdgeSense ChamferEdgeStart{X=48mm Y=121mm Z=0.835mm} ChamferEdgeEnd{X=48mm Y=121mm Z=-0.835mm} ChamferEdgeMid{X=48mm Y=121mm Z=0mm} ChamferEdgeMidTangent(0, 0, -1)}})
  Box20 = box(corner=(-58.25mm, 73mm, 0.835mm), size=(106.25mm, -12.065mm, -1.67mm))
  AntennaCut1.unite(Box20)
  Fintenna2.subtract(AntennaCut1)
  Fintenna_1 = Fintenna2.copy()
  Substrate1 = box(corner=(48mm, $Radius, 0.8mm), size=((-4.25*25) mm, 48mm, -1.6mm))
  Substrate1.chamfer(Edges=Substrate1.edge(at (-58.25, 121, 0)) LeftDistance=48mm RightDistance="(2.25*25) mm" ChamferType="Left Distance-Right Distance" ChamferAdditionalGeometryInfo{ChamferEdgeGeometryInfo{ChamferEdgeID=7315 ChamferEdgeSense ChamferEdgeStart{X=-58.25mm Y=121mm Z=0.8mm} ChamferEdgeEnd{X=-58.25mm Y=121mm Z=-0.8mm} ChamferEdgeMid{X=-58.25mm Y=121mm Z=0mm} ChamferEdgeMidTangent(0, 0, -1)}})
  Substrate1.chamfer(Edges=Substrate1.edge(at (48, 121, 0)) LeftDistance=6.25mm RightDistance=48mm ChamferType="Left Distance-Right Distance" ChamferAdditionalGeometryInfo{ChamferEdgeGeometryInfo{ChamferEdgeID=7316 ChamferEdgeSense ChamferEdgeStart{X=48mm Y=121mm Z=0.8mm} ChamferEdgeEnd{X=48mm Y=121mm Z=-0.8mm} ChamferEdgeMid{X=48mm Y=121mm Z=0mm} ChamferEdgeMidTangent(0, 0, -1)}})
  Box19 = box(corner=(-58.25mm, 73mm, 0.8mm), size=(106.25mm, -12.065mm, -1.6mm))
  Substrate1.unite(Box19)
  Substrate_1 = Substrate1.copy()
  Fuselage.subtract(Fintenna_1, Substrate_1)
  Substrate1.delete()
  CutTool = box(corner=(48mm, $Radius, 0.835mm), size=((-4.25*25) mm, 48mm, -1.67mm))
  CutTool.chamfer(Edges=CutTool.edge(at (-58.25, 121, 0)) LeftDistance=48mm RightDistance="(2.25*25) mm" ChamferType="Left Distance-Right Distance" ChamferAdditionalGeometryInfo{ChamferEdgeGeometryInfo{ChamferEdgeID=7857 ChamferEdgeSense ChamferEdgeStart{X=-58.25mm Y=121mm Z=0.835mm} ChamferEdgeEnd{X=-58.25mm Y=121mm Z=-0.835mm} ChamferEdgeMid{X=-58.25mm Y=121mm Z=0mm} ChamferEdgeMidTangent(0, 0, -1)}})
  CutTool.chamfer(Edges=CutTool.edge(at (48, 121, 0)) LeftDistance=6.25mm RightDistance=48mm ChamferType="Left Distance-Right Distance" ChamferAdditionalGeometryInfo{ChamferEdgeGeometryInfo{ChamferEdgeID=7858 ChamferEdgeSense ChamferEdgeStart{X=48mm Y=121mm Z=0.835mm} ChamferEdgeEnd{X=48mm Y=121mm Z=-0.835mm} ChamferEdgeMid{X=48mm Y=121mm Z=0mm} ChamferEdgeMidTangent(0, 0, -1)}})
  Box21 = box(corner=(-58.25mm, 73mm, 0.835mm), size=(106.25mm, -12.065mm, -1.67mm))
  CutTool.unite(Box21)
  CutTool_1 = CutTool.copy()
  CutTool_2 = CutTool.copy()
  FinFoot3 = imported_body(C:\Users\Garrett W\Documents\[A3-FIN] fintenna_assembly\[A3-FIN] fintenna_assembly - Part 2.step)
  FinFoot3.rotate(axis=Y, angle=-90deg)
  FinFoot3.rotate(axis=Z, angle=90deg)
  FinFoot3.move(-62.5mm, 70.46mm, 7.16915mm)
  FinFoot_1 = FinFoot3.copy()
  FinFoot_2 = FinFoot3.copy()
  FinFoot2 = imported_body(C:\Users\Garrett W\Documents\[A3-FIN] fintenna_assembly\[A3-FIN] fintenna_assembly - Part 1.step)
  FinFoot2.rotate(axis=Y, angle=-90deg)
  FinFoot2.rotate(axis=Z, angle=90deg)
  FinFoot2.move(-62.5mm, 70.46mm, 2.38125mm)
  FinFoot1_1 = FinFoot2.copy()
  FinFoot1_2 = FinFoot2.copy()
  Fintenna_2 = Fintenna2.copy()
  Fintenna_3 = Fintenna2.copy()
  Fuselage.subtract(CutTool_2, FinFoot_2, FinFoot1_2, Fintenna_3)
  [Fintenna2, FinFoot2, FinFoot3, CutTool].delete()
  Coupler [aluminum] = cylinder(axis=X, base_centre=(-100mm, 0mm, 0mm), radius=70.6mm, height=200mm, segments=32)
  Cylinder5 = cylinder(axis=X, base_centre=(100mm, 0mm, 0mm), radius=(70.6-3.175) mm, height=-200mm)
  Coupler.subtract(Cylinder5)
  Coupler.subtract(CutTool_1, FinFoot_1, FinFoot1_1, Fintenna_2)
  group Fintenna1 = Fintenna
  group Part2 = FinFoot1
  group Part3 = FinFoot
boundaries and excitations:
  Rad1: Radiation Objects=Box13
  1: Lumped Port Objects=Rectangle1 LumpedPortType=Modal Modes{Mode1{IntLine{(-5.05, 61, 0.835) -> (-5.05, 61, -0.835)} CharImp=Zpi}} Impedance=50ohm
setups:
  Setup1: HfssDriven Frequency=915MHz MaxDeltaS=0.02 MaximumPasses=12 MinimumPasses=1 MinimumConvergedPasses=1 PercentRefinement=30 BasisOrder=1 PortAccuracy=2 DrivenSolverType="Direct Solver" InfiniteSphereSetup=1
    sweep Sweep: 700MHz to 1100MHz, 200 points; Type=Interpolating InterpTolerance=0.5 InterpMaxSolns=250 PassivityErrorTolerance=0.0001
source amplitudes:
  1:1: 1V 0deg
radiation setups:
  Infinite Sphere1: Infinite Sphere Theta=0deg..180deg step 2deg Phi=-180deg..180deg step 2deg
reports:
  Gain Plot1: dB(GainTotal) vs Phi, Theta on Setup1 : LastAdaptive, Infinite Sphere1 [Freq=0.915GHz]
  Terminal VSWR Plot1: VSWRt(1) vs Freq on Setup1 : Sweep
  Terminal S Parameter Plot1: dB(St(1,1)) vs Freq on Setup1 : Sweep

design HFSSDesign2 (HFSS, HFSS Terminal Network, model units mm)
geometry:
  Substrate [FR4_epoxy] = box(corner=(50mm, $Radius, 0.8mm), size=((((-4.5*25)*0.03937007874015748)*25.399999999999999) mm, 40mm, -1.6mm))
  Substrate.chamfer(Edges=Substrate.edge(at (-62.5, 113, 0)) LeftDistance=40mm RightDistance="(((2.25*25)*0.03937007874015748)*25.399999999999999) mm" ChamferType="Left Distance-Right Distance" ChamferAdditionalGeometryInfo{ChamferEdgeGeometryInfo{ChamferEdgeID=23 ChamferEdgeSense ChamferEdgeStart{X=-62.5mm Y=113mm Z=0.8mm} ChamferEdgeEnd{X=-62.5mm Y=113mm Z=-0.8mm} ChamferEdgeMid{X=-62.5mm Y=113mm Z=0mm} ChamferEdgeMidTangent(0, 0, -1)}})
  Substrate.chamfer(Edges=Substrate.edge(at (50, 113, 0)) LeftDistance=6.25mm RightDistance=40mm ChamferType="Left Distance-Right Distance" ChamferAdditionalGeometryInfo{ChamferEdgeGeometryInfo{ChamferEdgeID=24 ChamferEdgeSense ChamferEdgeStart{X=50mm Y=113mm Z=0.8mm} ChamferEdgeEnd{X=50mm Y=113mm Z=-0.8mm} ChamferEdgeMid{X=50mm Y=113mm Z=0mm} ChamferEdgeMidTangent(0, 0, -1)}})
  coordinate_system RelativeCS1 = origin=(-20mm, $Radius+$PlaneWidth, 0.8mm) x=(1mm, 0mm, 0mm) y=(0mm, 1mm, 0mm)
  Finger = box(corner=(17.5mm, -$PlaneWidth, 0mm), size=(-5mm, -4.4mm, -1.6mm)) in RelativeCS1
  Substrate.unite(Finger)
  ViaHole = cylinder(axis=Z, base_centre=($FeedGap-1.25mm, -1mm, -1.635mm), radius=0.25mm, height=1.67mm) in RelativeCS1
  ViaHole.duplicate_along_line(step=(0mm, -1.5mm, 0mm), total=5, attached) in RelativeCS1
  ViaHole.duplicate_along_line(step=(4mm, 0mm, 0mm), total=2, attached) in RelativeCS1
  ViaHole_1 = ViaHole.copy()
  ViaHole_2 = ViaHole.copy()
  Substrate.subtract(ViaHole_2)
  TopGround [copper] = box(corner=(-20mm, $Radius, 0.8mm), size=(60mm, $PlaneWidth, 0.035mm))
  TopGround.chamfer(Edges=TopGround.edge(at (-20, 81, 0.8175)) LeftDistance=55deg RightDistance=$PlaneWidth ChamferType="Right Distance-Angle" ChamferAdditionalGeometryInfo{ChamferEdgeGeometryInfo{ChamferEdgeID=2238 ChamferEdgeSense ChamferEdgeStart{X=-30mm Y=81mm Z=0.8mm} ChamferEdgeEnd{X=-30mm Y=81mm Z=0.835mm} ChamferEdgeMid{X=-30mm Y=81mm Z=0.8175mm} ChamferEdgeMidTangent(0, 0, 1)}})  # suppressed
  TopGround.chamfer(Edges=TopGround.edge(at (40, 81, 0.8175)) LeftDistance=$PlaneWidth RightDistance=10deg ChamferType="Left Distance-Angle" ChamferAdditionalGeometryInfo{ChamferEdgeGeometryInfo{ChamferEdgeID=2239 ChamferEdgeSense ChamferEdgeStart{X=720mm Y=81mm Z=0.8mm} ChamferEdgeEnd{X=720mm Y=81mm Z=0.835mm} ChamferEdgeMid{X=720mm Y=81mm Z=0.8175mm} ChamferEdgeMidTangent(0, 0, 1)}})  # suppressed
  StripCutTool = box(corner=($FeedGap-0.6mm, 8mm-$PlaneWidth, 0mm), size=(2.7mm, -10mm, 0.035mm)) in RelativeCS1
  TopGround.subtract(StripCutTool)
  ViaHole_3 = ViaHole.copy()
  TopGround.subtract(ViaHole_3)
  ViaHole.delete()
  RadElement [copper] = box(corner=(0mm, $StubLen, 0mm), size=($RadLen, 1mm, 0.035mm)) in RelativeCS1
  Box16 = box(corner=($FeedGap, $StubLen, 0mm), size=(1.5mm, -($StubLen+$PlaneWidth+4.4mm), 0.035mm)) in RelativeCS1
  Box15 = box(corner=(0mm, $StubLen, 0mm), size=(1mm, -($StubLen), 0.035mm)) in RelativeCS1
  RadElement.unite(Box16, Box15)
  RadElement.chamfer(Edges=RadElement.edge(at (-19, 101, 0.8175)) LeftDistance=$Chamfer RightDistance=$Chamfer ChamferType=Symmetric ChamferAdditionalGeometryInfo{ChamferEdgeGeometryInfo{ChamferEdgeID=650 ChamferEdgeSense ChamferEdgeStart{X=-19mm Y=101mm Z=0.8mm} ChamferEdgeEnd{X=-19mm Y=101mm Z=0.835mm} ChamferEdgeMid{X=-19mm Y=101mm Z=0.8175mm} ChamferEdgeMidTangent(0, 0, 1)}})
  RadElement.chamfer(Edges=RadElement.edge(at (-20, 102, 0.8175)) LeftDistance=$Chamfer+0.6mm RightDistance=$Chamfer+0.6mm ChamferType=Symmetric ChamferAdditionalGeometryInfo{ChamferEdgeGeometryInfo{ChamferEdgeID=199 ChamferEdgeSense ChamferEdgeStart{X=-20mm Y=102mm Z=0.8mm} ChamferEdgeEnd{X=-20mm Y=102mm Z=0.835mm} ChamferEdgeMid{X=-20mm Y=102mm Z=0.8175mm} ChamferEdgeMidTangent(0, 0, 1)}})
  Fuselage [CF - Carbon fiber] = cylinder(axis=X, base_centre=(-150mm, 0mm, 0mm), radius=73mm, height=300mm, segments=32)
  Cylinder3 = cylinder(axis=X, base_centre=(200mm, 0mm, 0mm), radius=70mm, height=-400mm)
  Fuselage.subtract(Cylinder3)
  FuselageHole = cylinder(axis=Y, base_centre=($FeedGap+.75mm, -$PlaneWidth, 0.035mm), radius=3.5mm, height=-15mm) in RelativeCS1
  Fuselage.subtract(FuselageHole)
  ConnectorBridge [copper] = cylinder(axis=Y, base_centre=($FeedGap+.75mm, -$PlaneWidth, 0.035mm), radius=4.5mm/2, height=-4.4mm) in RelativeCS1
  Cylinder5 = cylinder(axis=Y, base_centre=($FeedGap+.75mm, -$PlaneWidth, 0.035mm), radius=2.7mm/2, height=-4.4mm) in RelativeCS1
  ConnectorBridge.subtract(Cylinder5)
  Box17 = box(corner=(17.5mm, -$PlaneWidth, 0mm), size=(-5mm, -4.4mm, -2.5mm)) in RelativeCS1
  ConnectorBridge.subtract(Box17)
  Rectangle1 = rectangle(corner=($FeedGap, -($PlaneWidth+4.4mm), 0mm), z_size=2mm, x_size=1.5mm) in RelativeCS1
  BottomGround [copper] = box(corner=(-20mm, $Radius, -0.8mm), size=(60mm, $PlaneWidth, -0.035mm))
  BottomGround.subtract(ViaHole_1)
  Vias [copper] = cylinder(axis=Z, base_centre=($FeedGap-1.25mm, -1mm, -1.635mm), radius=0.25mm, height=1.67mm) in RelativeCS1
  Vias.duplicate_along_line(step=(0mm, -1.5mm, 0mm), total=5, attached) in RelativeCS1
  Vias.duplicate_along_line(step=(4mm, 0mm, 0mm), total=2, attached) in RelativeCS1
  Vias1 = cylinder(axis=Z, base_centre=($FeedGap-1.25mm, -1mm, -1.635mm), radius=0.215mm, height=1.67mm) in RelativeCS1
  Vias1.duplicate_along_line(step=(0mm, -1.5mm, 0mm), total=5, attached) in RelativeCS1
  Vias1.duplicate_along_line(step=(4mm, 0mm, 0mm), total=2, attached) in RelativeCS1
  Vias.subtract(Vias1)
  BottomGround_1 [copper] = BottomGround.duplicate_mirror(point=(0mm, 0mm, 0mm), normal=(0mm, -1mm, 0mm))
  ConnectorBridge_1 [copper] = ConnectorBridge.duplicate_mirror(point=(0mm, 0mm, 0mm), normal=(0mm, -1mm, 0mm))
  RadElement_1 [copper] = RadElement.duplicate_mirror(point=(0mm, 0mm, 0mm), normal=(0mm, -1mm, 0mm))
  TopGround_1 [copper] = TopGround.duplicate_mirror(point=(0mm, 0mm, 0mm), normal=(0mm, -1mm, 0mm))
  Vias_1 [copper] = Vias.duplicate_mirror(point=(0mm, 0mm, 0mm), normal=(0mm, -1mm, 0mm))
  Substrate_1 [FR4_epoxy] = Substrate.duplicate_mirror(point=(0mm, 0mm, 0mm), normal=(0mm, -1mm, 0mm))
  Rectangle1_1 = Rectangle1.duplicate_mirror(point=(0mm, 0mm, 0mm), normal=(0mm, -1mm, 0mm))
  FuselageHole1 = cylinder(axis=Y, base_centre=($FeedGap+.75mm -20mm, -($Radius+$PlaneWidth), 0.035mm), radius=3.5mm, height=15mm)
  Fuselage.subtract(FuselageHole1)
  Box13 [air] = box(corner=(-150mm, 125mm, 100mm), size=(300mm, -250mm, -200mm))
boundaries and excitations:
  Rad1: Radiation Objects=Box13
  1: Lumped Port Objects=Rectangle1 LumpedPortType=Modal Modes{Mode1{IntLine{(-5.05, 68.6, 2.8) -> (-5, 68.6, 0.8)} CharImp=Zpi}} Impedance=50ohm
  2: Lumped Port Objects=Rectangle1_1 LumpedPortType=Modal Modes{Mode1{IntLine{(-5.05, -68.6, 2.8) -> (-5, -68.6, 0.8)} CharImp=Zpi}} Impedance=50ohm
mesh:
  ModelResolution1: DefeatureBased Objects=Fuselage auto length
setups:
  Setup1: HfssDriven Frequency=915MHz MaxDeltaS=0.02 MaximumPasses=12 MinimumPasses=1 MinimumConvergedPasses=1 PercentRefinement=30 BasisOrder=1 PortAccuracy=2 DrivenSolverType="Direct Solver" InfiniteSphereSetup=0
    sweep Sweep: 700MHz to 1100MHz, 200 points; Type=Interpolating InterpTolerance=0.5 InterpMaxSolns=250 PassivityErrorTolerance=0.0001
source amplitudes:
  1:1, 2:1: 1V 0deg
radiation setups:
  Infinite Sphere1: Infinite Sphere Theta=0deg..180deg step 2deg Phi=-180deg..180deg step 2deg

# Ansys Electronics Desktop project, version 2025.2
project variables:
  $poffset = 37mm
  $length = (68.348266643441*.99) mm
materials:
  vacuum: permittivity=1
  copper: permeability=0.999991 conductivity=58000000
  air: permittivity=1.0006 permeability=1.0000004
  graphite: conductivity=70000
  FR4_epoxy: permittivity=4.4 dielectric_loss_tangent=0.02
  cast_iron: permeability=60 conductivity=1500000
  CF - Carbon fiber: conductivity=252.337
  aluminum: permeability=1.000021 conductivity=38000000

design HFSSDesign1 (HFSS, HFSS Terminal Network, model units mm)
geometry:
  Box10 [FR4_epoxy] = box(corner=(50mm, (73+40) mm, 0.8mm), size=(-100mm, -40mm, -1.6mm))
  Cylinder2 [CF - Carbon fiber] = cylinder(axis=X, base_centre=(-200mm, 0mm, 0mm), radius=73mm, height=400mm, segments=32)
  Cylinder3 = cylinder(axis=X, base_centre=(200mm, 0mm, 0mm), radius=70mm, height=-400mm)
  Cylinder2.subtract(Cylinder3)
  Box13 [air] = box(corner=(-250mm, 200mm, 100mm), size=(500mm, -400mm, -200mm))
  Cylinder4 [aluminum] = cylinder(axis=X, base_centre=(-100mm, 0mm, 0mm), radius=70mm, height=200mm, segments=32)
  Cylinder5 = cylinder(axis=X, base_centre=(100mm, 0mm, 0mm), radius=66.5mm, height=-200mm)
  Cylinder4.subtract(Cylinder5)
  Box1 [copper] = box(corner=(0.1mm, 0mm, 0mm), size=(($length*0.6-2.1mm) meter, 2mm, 0.035mm))
  coordinate_system RelativeCS1 = origin=($length*0.6-2mm, 0mm, 0mm) x=(1mm, 0mm, 0mm) y=(0mm, 1mm, 0mm)
  Box4 = box(corner=(($length)*0.6-2mm, 0mm, 0mm), size=(2mm, $length*0.4, 0.035mm))
  Box4.rotate(axis=Z, angle=15deg) in RelativeCS1
  Box1.unite(Box4)
  Box1.mirror(point=(0mm, 0mm, 0mm), normal=(-1mm, 0mm, 0mm))
  Box1.rotate(axis=Z, angle=19.19deg)
  Box1.move_faces(MoveAlongNormalFlag=true OffsetDistance=-$poffset-0.3mm FacesToMove=Box1.face(at (-0.423145, 0.911564, 0.0175)))
  Box8 [copper] = box(corner=(-0.1mm, 0mm, 0mm), size=((-$length*0.6+1.9mm) meter, 2mm, 0.035mm))
  coordinate_system RelativeCS2 = origin=(-$length*0.6+1.8mm, 2mm, 0mm) x=(1mm, 0mm, 0mm) y=(0mm, 1mm, 0mm)
  Box9 = box(corner=(-($length)*0.6-0.2mm, 2mm, 0mm), size=(2mm, -$length*0.4, 0.035mm))
  Box9.rotate(axis=Z, angle=15deg) in RelativeCS2
  Box8.unite(Box9)
  Box8.mirror(point=(0mm, 0mm, 0mm), normal=(-1mm, 0mm, 0mm))
  Box8.rotate(axis=Z, angle=19.19deg)
  Box8.move_faces(MoveAlongNormalFlag=true OffsetDistance=$poffset FacesToMove=Box8.face(at (-0.234258, 0.977304, 0.0175)))
  [Box1, Box8].move(0mm, 92mm, 0.8mm)
  Box14 = box(corner=(-34.849606mm, 79.870903mm, 0.8mm), size=(1mm, -6mm, 0.035mm))
  Box15 = box(corner=(-36.349606mm, 79.870903mm, 0.8mm), size=(1mm, -6mm, 0.035mm))
  coordinate_system RelativeCS3 = origin=(-34.849606mm, 79.870903mm, 0.8mm) x=(1mm, 0mm, 0mm) y=(0mm, 1mm, 0mm)
  [Box15, Box14].rotate(axis=Z, angle=19.19deg) in RelativeCS3
  Box8.unite(Box14)
  Box1.unite(Box15)
  Rectangle1 = rectangle(corner=(0.55556027mm, -6.1596552mm, 0mm), x_size=2.5mm, y_size=-0.5mm) in RelativeCS3
  coordinate_system RelativeCS4 = origin=(-34.294045mm, 73.711248mm, 0.8mm) x=(1mm, 0mm, 0mm) y=(0mm, 1mm, 0mm)
  Rectangle1.rotate(axis=Z, angle=19.19deg) in RelativeCS4
  Box16 = box(corner=(-38.1mm, 79.870903mm, 0.8mm), size=(6mm, -6mm, 0.035mm))
  coordinate_system RelativeCS5 = origin=(-34.849606mm, 79.870903mm, 0.8mm) x=(1mm, 0mm, 0mm) y=(0mm, 1mm, 0mm)
  Box16.rotate(axis=Z, angle=19.19deg) in RelativeCS5
boundaries and excitations:
  Rad1: Radiation Objects=Box13
  Box8_T1: Terminal port=1 Edges=Box8.edge(at (-32.4052, 74.3687, 0.8)) TerminalResistance=50ohm
  1: Lumped Port Faces=Rectangle1.face(at (-33.0313, 73.886, 0.8)) LumpedPortType=Terminal Impedance=50ohm
  reference conductors: Box1
setups:
  Setup1: HfssDriven Frequency=915MHz MaxDeltaS=0.02 MaximumPasses=10 MinimumPasses=1 MinimumConvergedPasses=1 PercentRefinement=30 BasisOrder=1 PortAccuracy=2 DrivenSolverType="Direct Solver"
    sweep Sweep: 800MHz to 1000MHz, 40 points; Type=Discrete SaveFields SaveRadFields
source amplitudes:
  1:1: 1V 0deg
radiation setups:
  Infinite Sphere1: Infinite Sphere Theta=0deg..180deg step 2deg Phi=-180deg..180deg step 2deg
reports:
  Gain Plot1: dB(GainTotal) vs Phi, Theta on Setup1 : LastAdaptive, Infinite Sphere1 [Freq=0.915GHz]
  Terminal S Parameter Plot1: dB(St(Box8_T1,Box8_T1)) vs Freq on Setup1 : Sweep
  Terminal VSWR Plot1: VSWRt(Box8_T1) vs Freq on Setup1 : Sweep

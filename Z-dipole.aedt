# Ansys Electronics Desktop project, version 2025.2
project variables:
  $length = (68.348266643441*.99) mm
  $poffset = 37mm  # optimise 0mm..6mm
materials:
  vacuum: permittivity=1
  copper: permeability=0.999991 conductivity=58000000
  air: permittivity=1.0006 permeability=1.0000004
  graphite: conductivity=70000
  FR4_epoxy: permittivity=4.4 dielectric_loss_tangent=0.02
  cast_iron: permeability=60 conductivity=1500000
  CF - Carbon fiber: conductivity=252.337

design HFSSDesign1 (HFSS, HFSS Terminal Network, model units mm)
geometry:
  Cylinder1 [air] = cylinder(axis=X, base_centre=(-205mm, -50mm, 0mm), radius=150mm, height=410mm)
  Box1 [copper] = box(corner=(0.1mm, 0mm, 0mm), size=(($length*0.6-2.1mm) meter, 2mm, 0.035mm))
  Rectangle2 = rectangle(corner=(-0.1mm, 0mm, 0mm), x_size=0.2mm, y_size=2mm)
  Box4 = box(corner=(($length)*0.6-2mm, 0mm, 0mm), size=(2mm, $length*0.4, 0.035mm))
  Box8 [copper] = box(corner=(-0.1mm, 0mm, 0mm), size=((-$length*0.6+1.9mm) meter, 2mm, 0.035mm))
  Box9 = box(corner=(-($length)*0.6-0.2mm, 2mm, 0mm), size=(2mm, -$length*0.4, 0.035mm))
  coordinate_system RelativeCS1 = origin=($length*0.6-2mm, 0mm, 0mm) x=(1mm, 0mm, 0mm) y=(0mm, 1mm, 0mm)
  Box4.rotate(axis=Z, angle=15deg) in RelativeCS1
  coordinate_system RelativeCS2 = origin=(-$length*0.6+1.8mm, 2mm, 0mm) x=(1mm, 0mm, 0mm) y=(0mm, 1mm, 0mm)
  Box9.rotate(axis=Z, angle=15deg) in RelativeCS2
  Box8.unite(Box9)
  Box1.unite(Box4)
  [Box1, Box8, Rectangle2].mirror(point=(0mm, 0mm, 0mm), normal=(-1mm, 0mm, 0mm))
  [Box1, Box8, Rectangle2].rotate(axis=Z, angle=19.19deg)
  Box10 [FR4_epoxy] = box(corner=(50mm, 20mm, 0mm), size=(-100mm, -40mm, -1.6mm))
  Cylinder2 [CF - Carbon fiber] = cylinder(axis=X, base_centre=(-200mm, -97.1mm, 0mm), radius=77.1mm, height=400mm)
  Cylinder3 = cylinder(axis=X, base_centre=(200mm, -97.1mm, 0mm), radius=74mm, height=-400mm)
  Cylinder2.subtract(Cylinder3)
  Box1.move_faces(MoveAlongNormalFlag=true OffsetDistance=-$poffset FacesToMove=Box1.face(at (-0.423145, 0.911564, 0.0175)))
  Box8.move_faces(MoveAlongNormalFlag=true OffsetDistance=$poffset FacesToMove=Box8.face(at (-0.234258, 0.977304, 0.0175)))
  coordinate_system RelativeCS3 = origin=(0mm, 0mm, 0mm) x=(-0.094443375mm, -0.032870182mm, 0mm) y=(0.1mm, 0.1mm, 0mm)
  Rectangle2.move($poffset, 0mm, 0mm) in RelativeCS3
boundaries and excitations:
  Rad1: Radiation Objects=Cylinder1
  Box7_T1: Terminal port=1 Edges=Box8.edge(at (-35.1783, -11.1847, 0)) TerminalResistance=50ohm
  1: Lumped Port Faces=Rectangle2.face(at (-35.2728, -11.2175, 0)) LumpedPortType=Terminal Impedance=50ohm
setups:
  Setup1: HfssDriven Frequency=915MHz MaxDeltaS=0.02 MaximumPasses=6 MinimumPasses=1 MinimumConvergedPasses=1 PercentRefinement=30 BasisOrder=1 PortAccuracy=2 DrivenSolverType="Direct Solver"
    sweep Sweep: 900MHz to 1000MHz, 20 points; Type=Discrete SaveFields SaveRadFields
source amplitudes:
  1:1: 1 0deg
optimetrics:
  OptimizationSetup1: Optimization disabled Optimizer="kDX ASO" AnalysisStopOptions{StopForNumIteration MaxNumIteration=32 MinNumIteration=10} CostFuncNormType=L2 Acceptable_Cost=0 Noise=0.0001 UpdateDesignWhenDone
    vary $poffset: Min=0mm Max=37mm MinStep=0.03mm MaxStep=0.3mm MinFocus=0mm MaxFocus=6mm start=35mm
    goal dB(St(Box7_T1,Box7_T1)) Minimize 0 weight 1 on Setup1 : LastAdaptive at Freq 0.915GHz
  OptimizationSetup2: Optimization disabled Optimizer="kDX ASO" AnalysisStopOptions{StopForNumIteration MaxNumIteration=32 MinNumIteration=10} CostFuncNormType=L2 Acceptable_Cost=0 Noise=0.0001 UpdateDesignWhenDone
    vary $poffset: Min=0mm Max=37mm MinStep=0.03mm MaxStep=0.3mm MinFocus=0mm MaxFocus=6mm start=3mm
    goal VSWRt(Box7_T1) == 1 weight 1 on Setup1 : LastAdaptive at Freq 0.915GHz
radiation setups:
  Infinite Sphere1: Infinite Sphere Theta=0deg..180deg step 2deg Phi=-180deg..180deg step 2deg
reports:
  Gain Plot1: dB(GainTotal) vs Phi, Theta on Setup1 : LastAdaptive, Infinite Sphere1 [Freq=0.915GHz]
  Gain Plot2: dB(GainTotal) vs Phi on Setup1 : LastAdaptive, Infinite Sphere1 [Theta=90deg Freq=all]
  Terminal S Parameter Plot1: dB(St(Box7_T1,Box7_T1)) vs Freq on Setup1 : Sweep
  Terminal VSWR Plot1: VSWRt(Box7_T1) vs Freq on Setup1 : Sweep
  Terminal Z Parameter Plot1: re(Zt(Box7_T1,Box7_T1)) vs Freq on Setup1 : Sweep
  Terminal Z Parameter Plot2: im(Zt(Box7_T1,Box7_T1)) vs Freq on Setup1 : Sweep
  Terminal VSWR Plot2: VSWRt(Box7_T1) vs Freq on Setup1 : LastAdaptive

# Ansys Electronics Desktop project, version 2025.2
project variables:
  $Radius = 73mm
  $RadLen = 26mm
  $RadWidth = 2mm
  $FeedX = 70mm
  $FeedY = 30mm
  $LineWidth = (1.1*0.8) mm
  $LineGap = (0.22*0.8) mm
materials:
  vacuum: permittivity=1
  copper: permeability=0.999991 conductivity=58000000
  air: permittivity=1.0006 permeability=1.0000004
  graphite: conductivity=70000
  FR4_epoxy: permittivity=4.4 dielectric_loss_tangent=0.02
  cast_iron: permeability=60 conductivity=1500000
  CF - Carbon fiber: conductivity=252.337
  aluminum: permeability=1.000021 conductivity=38000000
  cyanate_ester: permittivity=3.8

design HFSSDesign1 (HFSS, HFSS Terminal Network, model units mm)
geometry:
  Substrate [FR4_epoxy] = box(corner=(48mm, $Radius, 0.8mm), size=((-4.25*25) mm, 48mm, -1.6mm))
  Fuselage [CF - Carbon fiber] = cylinder(axis=X, base_centre=(-200mm, 0mm, 0mm), radius=73mm, height=400mm, segments=32)
  Cylinder3 = cylinder(axis=X, base_centre=(200mm, 0mm, 0mm), radius=70.6mm, height=-400mm)
  Fuselage.subtract(Cylinder3)
  Box13 [air] = box(corner=(-250mm, 200mm, 100mm), size=(500mm, -400mm, -200mm))
  Coupler [aluminum] = cylinder(axis=X, base_centre=(-100mm, 0mm, 0mm), radius=70.6mm, height=200mm, segments=32)
  Cylinder5 = cylinder(axis=X, base_centre=(100mm, 0mm, 0mm), radius=(70.6-3.175) mm, height=-200mm)
  Coupler.subtract(Cylinder5)
  Substrate.chamfer(Edges=Substrate.edge(at (-58.25, 121, 0)) LeftDistance=48mm RightDistance="(2.25*25) mm" ChamferType="Left Distance-Right Distance" ChamferAdditionalGeometryInfo{ChamferEdgeGeometryInfo{ChamferEdgeID=1342 ChamferEdgeSense ChamferEdgeStart{X=-58.25mm Y=121mm Z=0.8mm} ChamferEdgeEnd{X=-58.25mm Y=121mm Z=-0.8mm} ChamferEdgeMid{X=-58.25mm Y=121mm Z=0mm} ChamferEdgeMidTangent(0, 0, -1)}})
  Substrate.chamfer(Edges=Substrate.edge(at (48, 121, 0)) LeftDistance=6.25mm RightDistance=48mm ChamferType="Left Distance-Right Distance" ChamferAdditionalGeometryInfo{ChamferEdgeGeometryInfo{ChamferEdgeID=1343 ChamferEdgeSense ChamferEdgeStart{X=48mm Y=121mm Z=0.8mm} ChamferEdgeEnd{X=48mm Y=121mm Z=-0.8mm} ChamferEdgeMid{X=48mm Y=121mm Z=0mm} ChamferEdgeMidTangent(0, 0, -1)}})
  Fintenna [cyanate_ester] = imported_body(C:\Users\Garrett W\Documents\[A3-FIN] fintenna_assembly\[A3-FIN] fintenna_assembly - Fintenna.step)
  Fintenna.rotate(axis=Z, angle=90deg)
  Fintenna.rotate(axis=Y, angle=-90deg)
  Fintenna.move(-62.5mm, 73mm, -2.38125mm)
  Box14 = box(corner=(-58.25mm, 73mm, 0.8mm), size=(106.25mm, -12.065mm, -1.6mm))
  Substrate.unite(Box14)
  Fintenna_1 = Fintenna.copy()
  Substrate_1 = Substrate.copy()
  Fuselage.subtract(Fintenna_1, Substrate_1)
  FinFoot1 [aluminum] = imported_body(C:\Users\Garrett W\Documents\[A3-FIN] fintenna_assembly\[A3-FIN] fintenna_assembly - Part 1.step)
  FinFoot [aluminum] = imported_body(C:\Users\Garrett W\Documents\[A3-FIN] fintenna_assembly\[A3-FIN] fintenna_assembly - Part 2.step)
  FinFoot1.rotate(axis=Y, angle=-90deg)
  FinFoot1.rotate(axis=Z, angle=90deg)
  FinFoot1.move(-62.5mm, 70.46mm, 2.38125mm)
  FinFoot.rotate(axis=Y, angle=-90deg)
  FinFoot.rotate(axis=Z, angle=90deg)
  FinFoot.move(-62.5mm, 70.46mm, 7.16915mm)
  CutTool = box(corner=(48mm, $Radius, 0.835mm), size=((-4.25*25) mm, 48mm, -1.67mm))
  CutTool.chamfer(Edges=CutTool.edge(at (-58.25, 121, 0)) LeftDistance=48mm RightDistance="(2.25*25) mm" ChamferType="Left Distance-Right Distance" ChamferAdditionalGeometryInfo{ChamferEdgeGeometryInfo{ChamferEdgeID=4487 ChamferEdgeSense ChamferEdgeStart{X=-58.25mm Y=121mm Z=0.835mm} ChamferEdgeEnd{X=-58.25mm Y=121mm Z=-0.835mm} ChamferEdgeMid{X=-58.25mm Y=121mm Z=0mm} ChamferEdgeMidTangent(0, 0, -1)}})
  CutTool.chamfer(Edges=CutTool.edge(at (48, 121, 0)) LeftDistance=6.25mm RightDistance=48mm ChamferType="Left Distance-Right Distance" ChamferAdditionalGeometryInfo{ChamferEdgeGeometryInfo{ChamferEdgeID=4488 ChamferEdgeSense ChamferEdgeStart{X=48mm Y=121mm Z=0.835mm} ChamferEdgeEnd{X=48mm Y=121mm Z=-0.835mm} ChamferEdgeMid{X=48mm Y=121mm Z=0mm} ChamferEdgeMidTangent(0, 0, -1)}})
  Box16 = box(corner=(-58.25mm, 73mm, 0.835mm), size=(106.25mm, -12.065mm, -1.67mm))
  CutTool.unite(Box16)
  CutTool_1 = CutTool.copy()
  FinFoot_1 = FinFoot.copy()
  FinFoot1_1 = FinFoot1.copy()
  Fintenna_2 = Fintenna.copy()
  Coupler.subtract(CutTool_1, FinFoot_1, FinFoot1_1, Fintenna_2)
  CutTool_2 = CutTool.copy()
  CutTool.delete()
  FinFoot_2 = FinFoot.copy()
  FinFoot1_2 = FinFoot1.copy()
  Fintenna_3 = Fintenna.copy()
  Fuselage.subtract(CutTool_2, FinFoot_2, FinFoot1_2, Fintenna_3)
  coordinate_system RelativeCS1 = origin=(-58.25mm, $Radius, 0.835mm) x=(1mm, 0mm, 0mm) y=(0mm, 1mm, 0mm)
  Copper [copper] = box(corner=(0mm, -12.065mm, 0mm), size=(105mm, 57.065mm, 0.035mm)) in RelativeCS1
  Copper.chamfer(Edges=Copper.edge(at (-58.25, 118, 0.8525)) LeftDistance=55mm RightDistance=45mm ChamferType="Left Distance-Right Distance" ChamferAdditionalGeometryInfo{ChamferEdgeGeometryInfo{ChamferEdgeID=6199 ChamferEdgeSense ChamferEdgeStart{X=-58.25mm Y=118mm Z=0.835mm} ChamferEdgeEnd{X=-58.25mm Y=118mm Z=0.87mm} ChamferEdgeMid{X=-58.25mm Y=118mm Z=0.8525mm} ChamferEdgeMidTangent(0, 0, 1)}})
  Copper.chamfer(Edges=Copper.edge(at (46.75, 118, 0.8525)) LeftDistance=40mm RightDistance=5mm ChamferType="Left Distance-Right Distance" ChamferAdditionalGeometryInfo{ChamferEdgeGeometryInfo{ChamferEdgeID=6200 ChamferEdgeSense ChamferEdgeStart{X=46.75mm Y=118mm Z=0.835mm} ChamferEdgeEnd{X=46.75mm Y=118mm Z=0.87mm} ChamferEdgeMid{X=46.75mm Y=118mm Z=0.8525mm} ChamferEdgeMidTangent(0, 0, 1)}})
  LeftSlot = box(corner=($FeedX, $FeedY, 0mm), size=(-$RadLen, $RadWidth, 0.035mm)) in RelativeCS1
  RightSlot = box(corner=($FeedX+$LineWidth, $FeedY, 0mm), size=($RadLen, $RadWidth, 0.035mm)) in RelativeCS1
  LeftWaveguide = box(corner=($FeedX, $FeedY, 0mm), size=(-$LineGap, -($FeedY+10mm), 0.035mm)) in RelativeCS1
  RightWaveguide = box(corner=($FeedX+$LineWidth, $FeedY, 0mm), size=($LineGap, -($FeedY+10mm), 0.035mm)) in RelativeCS1
  ConnectorGap = box(corner=($FeedX-$LineGap, -10mm, 0mm), size=($LineGap*2+$LineWidth, -1mm, 0.035mm)) in RelativeCS1
  Copper.subtract(ConnectorGap, LeftSlot, LeftWaveguide, RightSlot, RightWaveguide)
  Rectangle1 = rectangle(corner=(70mm, -10mm, 0mm), x_size=$LineWidth, y_size=-1mm) in RelativeCS1
  Copper_1 = Copper.copy()
  Substrate_2 = Substrate.copy()
  Fintenna.subtract(Copper_1, Substrate_2)
  group Fintenna1 = Fintenna
  group Part2 = FinFoot1
  group Part3 = FinFoot
boundaries and excitations:
  Rad1: Radiation Objects=Box13
  1: Lumped Port Objects=Rectangle1 LumpedPortType=Modal Modes{Mode1{IntLine{(12.19, 62, 0.835) -> (12.19, 63, 0.835)} CharImp=Zpi}} Impedance=50ohm
mesh:
  initial mesh: GlobalSurfApproximation{CurvedSurfaceApproxChoice=UseSlider SliderMeshSettings=2} GlobalCurvilinear{Apply} MeshMethod=AnsoftClassic
setups:
  Setup1: HfssDriven Frequency=1.575GHz MaxDeltaS=0.02 MaximumPasses=10 MinimumPasses=1 MinimumConvergedPasses=1 PercentRefinement=30 BasisOrder=1 PortAccuracy=2 DrivenSolverType="Direct Solver" InfiniteSphereSetup=69
    sweep Sweep: 1000MHz to 2000MHz, 120 points; disabled Type=Interpolating SaveFields InterpTolerance=0.5 InterpMaxSolns=50 PassivityErrorTolerance=0.0001
    sweep Sweep1: 1.5GHz to 1.6GHz, 200 points; disabled Type=Discrete
    sweep QuickWideSweep: 0.7875GHz to 2.3625GHz, 401 points; Type=Interpolating SaveFields InterpTolerance=0.5 InterpMaxSolns=250 PassivityErrorTolerance=0.0001
source amplitudes:
  1:1: 1V 0deg
radiation setups:
  Infinite Sphere1: Infinite Sphere Theta=0deg..180deg step 2deg Phi=-180deg..180deg step 2deg
reports:
  Terminal S Parameter Plot1: dB(St(1,1)) vs Freq on Setup1 : QuickWideSweep
  Terminal VSWR Plot1: VSWRt(1) vs Freq on Setup1 : QuickWideSweep
  Gain Plot1: dB(GainTotal) vs Phi, Theta on Setup1 : LastAdaptive, Infinite Sphere1 [Freq=1.575GHz]
  Terminal S Parameter Plot2: dB(St(Box17_T1,Box17_T1)) vs Freq on Setup1 : Sweep1 [$RadLen=all]
  Terminal VSWR Plot2: VSWRt(Box17_T1) vs Freq on Setup1 : Sweep1 [$RadLen=all]
  Gain Plot2: dB(GainRHCP) vs Phi, Theta on Setup1 : LastAdaptive, Infinite Sphere1 [Freq=1.575GHz $RadLen=26mm]
  Gain Plot3: dB(GainTotal) vs Theta on Setup1 : LastAdaptive, Infinite Sphere1 [Phi=90deg Freq=1.575GHz $RadLen=26mm]

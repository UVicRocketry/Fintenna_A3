# Ansys Electronics Desktop project, version 2025.2
project variables:
  $Radius = 73mm
  $RadLen = 27.5mm  # optimise 10mm..35mm
  $RadWidth = 3mm
  $FeedX = 65mm
  $FeedY = 21.2mm
  $LineWidth = 1.47mm
  $TESTwidth = 1.5mm
  $TESTgap = 0.19mm
  $FeedOffset = 2mm+$GroundOffset
  $Angle = 45deg
  $GroundOffset = 5mm
  $Element = 5mm
  $PhaseLen = 10mm
materials:
  vacuum: permittivity=1
  copper: permeability=0.999991 conductivity=58000000
  air: permittivity=1.0006 permeability=1.0000004
  graphite: conductivity=70000
  FR4_epoxy: permittivity=4.4 dielectric_loss_tangent=0.02
  cast_iron: permeability=60 conductivity=1500000
  CF - Carbon fiber: conductivity=252.337
  aluminum: permeability=1.000021 conductivity=38000000
  cyanate_ester: permittivity=3.8

design HFSSDesign1 (HFSS, HFSS Terminal Network, model units mm)
geometry:
  Substrate [FR4_epoxy] = box(corner=(48mm, $Radius, 0.4mm), size=((-4.25*25) mm, 48mm, -0.8mm))
  Box13 [air] = box(corner=(-200mm, 200mm, 100mm), size=(400mm, -200mm, -200mm))
  Coupler [aluminum, non-model] = cylinder(axis=X, base_centre=(-100mm, 0mm, 0mm), radius=70.6mm, height=200mm, segments=32)
  Cylinder5 = cylinder(axis=X, base_centre=(100mm, 0mm, 0mm), radius=(70.6-3.175) mm, height=-200mm)
  Coupler.subtract(Cylinder5)
  Substrate.chamfer(Edges=Substrate.edge(at (-58.25, 121, 0)) LeftDistance=48mm RightDistance="(2.25*25) mm" ChamferType="Left Distance-Right Distance" ChamferAdditionalGeometryInfo{ChamferEdgeGeometryInfo{ChamferEdgeID=1342 ChamferEdgeSense ChamferEdgeStart{X=-58.25mm Y=121mm Z=0.4mm} ChamferEdgeEnd{X=-58.25mm Y=121mm Z=-0.4mm} ChamferEdgeMid{X=-58.25mm Y=121mm Z=0mm} ChamferEdgeMidTangent(0, 0, -1)}})
  Substrate.chamfer(Edges=Substrate.edge(at (48, 121, 0)) LeftDistance=6.25mm RightDistance=48mm ChamferType="Left Distance-Right Distance" ChamferAdditionalGeometryInfo{ChamferEdgeGeometryInfo{ChamferEdgeID=1343 ChamferEdgeSense ChamferEdgeStart{X=48mm Y=121mm Z=0.4mm} ChamferEdgeEnd{X=48mm Y=121mm Z=-0.4mm} ChamferEdgeMid{X=48mm Y=121mm Z=0mm} ChamferEdgeMidTangent(0, 0, -1)}})
  Fintenna [FR4_epoxy] = imported_body(C:\Users\Garrett W\Documents\[A3-FIN] fintenna_assembly\[A3-FIN] fintenna_assembly - Fintenna.step)
  Fintenna.rotate(axis=Z, angle=90deg)
  Fintenna.rotate(axis=Y, angle=-90deg)
  Fintenna.move(-62.5mm, 73mm, -2.38125mm)
  Box14 = box(corner=(-58.25mm, $Radius, 0.4mm), size=(106.25mm, -12mm, -0.8mm))
  Substrate.unite(Box14)
  FinFoot1 [aluminum, non-model] = imported_body(C:\Users\Garrett W\Documents\[A3-FIN] fintenna_assembly\[A3-FIN] fintenna_assembly - Part 1.step)
  FinFoot [aluminum, non-model] = imported_body(C:\Users\Garrett W\Documents\[A3-FIN] fintenna_assembly\[A3-FIN] fintenna_assembly - Part 2.step)
  FinFoot1.rotate(axis=Y, angle=-90deg)
  FinFoot1.rotate(axis=Z, angle=90deg)
  FinFoot1.move(-62.5mm, 70.46mm, 2.38125mm)
  FinFoot.rotate(axis=Y, angle=-90deg)
  FinFoot.rotate(axis=Z, angle=90deg)
  FinFoot.move(-62.5mm, 70.46mm, 7.16915mm)
  CutTool = box(corner=(48mm, $Radius, 0.835mm), size=((-4.25*25) mm, 48mm, -1.67mm))
  CutTool.chamfer(Edges=CutTool.edge(at (-58.25, 121, 0)) LeftDistance=48mm RightDistance="(2.25*25) mm" ChamferType="Left Distance-Right Distance" ChamferAdditionalGeometryInfo{ChamferEdgeGeometryInfo{ChamferEdgeID=4487 ChamferEdgeSense ChamferEdgeStart{X=-58.25mm Y=121mm Z=0.835mm} ChamferEdgeEnd{X=-58.25mm Y=121mm Z=-0.835mm} ChamferEdgeMid{X=-58.25mm Y=121mm Z=0mm} ChamferEdgeMidTangent(0, 0, -1)}})
  CutTool.chamfer(Edges=CutTool.edge(at (48, 121, 0)) LeftDistance=6.25mm RightDistance=48mm ChamferType="Left Distance-Right Distance" ChamferAdditionalGeometryInfo{ChamferEdgeGeometryInfo{ChamferEdgeID=4488 ChamferEdgeSense ChamferEdgeStart{X=48mm Y=121mm Z=0.835mm} ChamferEdgeEnd{X=48mm Y=121mm Z=-0.835mm} ChamferEdgeMid{X=48mm Y=121mm Z=0mm} ChamferEdgeMidTangent(0, 0, -1)}})
  Box16 = box(corner=(-58.25mm, 73mm, 0.835mm), size=(106.25mm, -12.065mm, -1.67mm))
  CutTool.unite(Box16)
  CutTool_1 = CutTool.copy()
  CutTool.delete()
  FinFoot_1 = FinFoot.copy()
  FinFoot1_1 = FinFoot1.copy()
  Fintenna_2 = Fintenna.copy()
  Coupler.subtract(CutTool_1, FinFoot_1, FinFoot1_1, Fintenna_2)
  coordinate_system RelativeCS1 = origin=(-58.25mm, $Radius, 0.435mm) x=(1mm, 0mm, 0mm) y=(0mm, 1mm, 0mm)
  Substrate.move_faces(MoveAlongNormalFlag=true OffsetDistance=15mm FacesToMove=Substrate.face(at (44.875, 97, 0), at (48, 67, 0))) in RelativeCS1  # suppressed
  Fuselage [CF - Carbon fiber] = imported_body()
  FeedLine [copper] = box(corner=($FeedX, -12mm, -0.835mm), size=($LineWidth, 12mm+$FeedOffset, -0.035mm)) in RelativeCS1
  Rectangle1 = rectangle(corner=($FeedX, -12mm, 0mm), z_size=-0.87mm, x_size=$LineWidth) in RelativeCS1
  FinFoot_2 = FinFoot.copy()
  FinFoot1_2 = FinFoot1.copy()
  Fuselage.subtract(FinFoot_2, FinFoot1_2)
  Ground [copper] = box(corner=(0mm, -12mm, 0mm), size=(105mm, 12mm+$GroundOffset, -0.035mm)) in RelativeCS1
  Ground.chamfer(Edges=Ground.edge(at (-58.25, 78, 0.4175)) LeftDistance=$GroundOffset RightDistance=55mm ChamferType="Left Distance-Right Distance" ChamferAdditionalGeometryInfo{ChamferEdgeGeometryInfo{ChamferEdgeID=19764 ChamferEdgeSense ChamferEdgeStart{X=-58.25mm Y=78mm Z=0.435mm} ChamferEdgeEnd{X=-58.25mm Y=78mm Z=0.4mm} ChamferEdgeMid{X=-58.25mm Y=78mm Z=0.4175mm} ChamferEdgeMidTangent(0, 0, -1)}})
  Ground.chamfer(Edges=Ground.edge(at (46.75, 78, 0.4175)) LeftDistance=5mm RightDistance=$GroundOffset ChamferType="Left Distance-Right Distance" ChamferAdditionalGeometryInfo{ChamferEdgeGeometryInfo{ChamferEdgeID=19765 ChamferEdgeSense ChamferEdgeStart{X=46.75mm Y=78mm Z=0.435mm} ChamferEdgeEnd{X=46.75mm Y=78mm Z=0.4mm} ChamferEdgeMid{X=46.75mm Y=78mm Z=0.4175mm} ChamferEdgeMidTangent(0, 0, -1)}})
  Ground.move_faces(MoveAlongNormalFlag=true OffsetDistance=15mm FacesToMove=Ground.face(at (46.75, 69.5325, 0.4175)) ?.face(at (44.25, 98.065, 0.4175))) in RelativeCS1  # suppressed
  RadElement = box(corner=($FeedX-$RadWidth/2+$LineWidth/2, $FeedOffset, -0.835mm), size=($RadWidth, $RadLen, -0.035mm)) in RelativeCS1
  FeedLine.fillet(Edges=FeedLine.edge(at (8.22, 80, -0.4175), at (6.75, 80, -0.4175)) Radius=($RadWidth-$LineWidth)/2 Setback=0mm)  # suppressed
  coordinate_system Rotation1 = origin=($FeedX+$LineWidth, $FeedOffset, -0.835mm) x=(1mm, 0mm, 0mm) y=(0mm, 1mm, 0mm) in RelativeCS1
  RadElement.rotate(axis=Z, angle=$Angle) in Rotation1
  FeedLine.unite(RadElement)
  FeedLine_1 = FeedLine.copy()
  Ground_1 = Ground.copy()
  Substrate_1 = Substrate.copy()
  Fintenna.subtract(FeedLine_1, Ground_1, Substrate_1)
  RadElement2 = box(corner=($FeedX-$RadWidth/2+$LineWidth/2 +$Element, $FeedOffset, -0.835mm), size=($RadWidth, $RadLen, -0.035mm)) in RelativeCS1
  coordinate_system Rotation2 = origin=($Element-$LineWidth, 0mm, 0mm) x=(1mm, 0mm, 0mm) y=(0mm, 1mm, 0mm) in Rotation1
  RadElement2.rotate(axis=Z, angle=-$angle) in Rotation2
  Rectangle2 = rectangle(corner=($FeedX+$Element, -12mm, 0mm), z_size=-0.87mm, x_size=$LineWidth) in RelativeCS1
  Feedline2 [copper] = box(corner=($FeedX+$Element, -12mm, -0.835mm), size=($LineWidth, 2mm, -0.035mm)) in RelativeCS1
  Box18 = box(corner=($FeedX+$Element, -10mm, -0.835mm), size=($PhaseLen, $LineWidth, -0.035mm)) in RelativeCS1
  Box19 = box(corner=($FeedX+$Element, -5mm+$LineWidth, -0.835mm), size=($LineWidth, $FeedOffset-$LineWidth+5mm, -0.035mm)) in RelativeCS1
  Box20 = box(corner=($FeedX+$Element, -5mm, -0.835mm), size=($PhaseLen, $LineWidth, -0.035mm)) in RelativeCS1
  Box21 = box(corner=($FeedX+$PhaseLen+$Element, -10mm, -0.835mm), size=($LineWidth, 5mm+$LineWidth, -0.035mm)) in RelativeCS1
  Feedline2.unite(Box18..Box21)
  Feedline2.unite(RadElement2)
  group Fintenna1 = Fintenna
  group Part2 = FinFoot1
  group Part3 = FinFoot
boundaries and excitations:
  Rad1: Radiation Objects=Box13
  1: Lumped Port Objects=Rectangle1 LumpedPortType=Modal Modes{Mode1{IntLine{(7.485, 61, 0.435) -> (7.485, 61, -0.435)} CharImp=Zpi}} Impedance=50ohm
  2: Lumped Port Objects=Rectangle2 LumpedPortType=Modal Modes{Mode1{IntLine{(12.485, 61, 0.435) -> (12.485, 61, -0.435)} CharImp=Zpi}} Impedance=50ohm
mesh:
  initial mesh: GlobalSurfApproximation{CurvedSurfaceApproxChoice=UseSlider SliderMeshSettings=1} GlobalCurvilinear{Apply} MeshMethod=AnsoftClassic DynamicSurfaceResolution
setups:
  Setup1: HfssDriven Frequency=1.575GHz MaxDeltaS=0.02 MaximumPasses=8 MinimumPasses=1 MinimumConvergedPasses=1 PercentRefinement=30 BasisOrder=1 PortAccuracy=2 DrivenSolverType="Direct Solver" InfiniteSphereSetup=69
    sweep Sweep: 1000MHz to 2000MHz, 120 points; disabled Type=Interpolating SaveFields InterpTolerance=0.5 InterpMaxSolns=50 PassivityErrorTolerance=0.0001
    sweep NarrorDiscrete: 1.5GHz to 1.6GHz, 200 points; disabled Type=Discrete SaveFields
    sweep QuickWideSweep: 0.5GHz to 10GHz, 401 points; disabled Type=Interpolating SaveFields InterpTolerance=0.5 InterpMaxSolns=250 PassivityErrorTolerance=0.0001
    sweep QuickNarrowSweep: 1GHz to 2GHz, 80 points; Type=Interpolating InterpTolerance=0.5 InterpMaxSolns=250 PassivityErrorTolerance=0.0001
source amplitudes:
  1:1: 1W 0deg
  2:1: 0W 0deg
optimetrics:
  OptimizationSetup1: Optimization disabled Optimizer="DX AMO" AnalysisStopOptions{StopForNumIteration MaxNumIteration=625 MinNumIteration=10} CostFuncNormType=L2 Acceptable_Cost=0 Noise=0.0001 UpdateDesignWhenDone
    vary $RadLen: Min=35mm Max=80mm MinStep=0.35mm MaxStep=3.5mm MinFocus=10mm MaxFocus=35mm start=60mm
    goal dB(St(1,1)) Minimize 0 weight 1 on Setup1 : LastAdaptive at Freq 1.575GHz
radiation setups:
  Infinite Sphere1: Infinite Sphere Theta=0deg..180deg step 2deg Phi=-180deg..180deg step 2deg
reports:
  Gain Plot1: dB(GainTotal) vs Phi, Theta on Setup1 : LastAdaptive, Infinite Sphere1 [Freq=1.575GHz]
  Gain Plot2: dB(GainRHCP) vs Phi, Theta on Setup1 : LastAdaptive, Infinite Sphere1 [Freq=1.575GHz]
  Axial Ratio Plot1: mag(AxialRatioValue) vs Phi on Setup1 : LastAdaptive, Infinite Sphere1 [Freq=1.575GHz Theta=38deg]; markers m1 at -116deg
  VSWR Plot1: VSWR(1) vs Freq on Setup1 : QuickNarrowSweep; markers m1 at 1.5751307GHz
  S Parameter Plot1: dB(S(1,1)) vs Freq on Setup1 : QuickNarrowSweep; markers m1 at 1.5749912GHz
  S Parameter Plot1_1: dB(S(1,1)) vs Freq on Setup1 : QuickWideSweep
  Terminal VSWR Plot1: VSWRt(1) vs Freq on Setup1 : QuickWideSweep; markers m1 at 1.5778894GHz
  Gain Plot3: dB(GainRHCP) vs Phi on Setup1 : LastAdaptive, Infinite Sphere1 [Theta=0deg,10deg,20deg,30deg,40deg,50deg,60deg,70deg,80deg,90deg,100deg,110deg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 Freq=1.575GHz]; markers m1 at 102deg
  Antenna Params Plot1: TotalEfficiency vs Freq on Setup1 : LastAdaptive
  rE Table1: cang_deg(rEY) vs Freq on Setup1 : LastAdaptive, Infinite Sphere1 [Phi=all Theta=90deg]

design HFSSDesign2 (HFSS, HFSS Terminal Network, model units mm)
geometry:
  Substrate [FR4_epoxy] = box(corner=(-20mm, 0mm, 0mm), size=(40mm, 40mm, 0.8mm))
  Copper [copper] = box(corner=(-20mm, 0mm, 0.8mm), size=(40mm, 40mm, 0.035mm))
  Slot2 = box(corner=($TESTwidth/2, 0mm, 0.8mm), size=($TESTgap, 40mm, 0.035mm))
  Slot1 = box(corner=(-$TESTwidth/2, 0mm, 0.8mm), size=(-$TESTgap, 40mm, 0.035mm))
  Copper.subtract(Slot1, Slot2)
  Rectangle1 = rectangle(corner=(-5mm, 0mm, -4mm), z_size=10mm, x_size=10mm)
  Rectangle2 = rectangle(corner=(-5mm, 40mm, -4mm), z_size=10mm, x_size=10mm)
  Box1 [vacuum] = box(corner=(-40mm, -20mm, -40mm), size=(80mm, 80mm, 80mm))
  Box2 [CF - Carbon fiber] = box(corner=(-25mm, 20mm, -25mm), size=(50mm, 1mm, 50mm))
  Box3 = box(corner=(-20mm, 20mm, -0.3mm), size=(40mm, 1mm, 2.5mm))
  Box2.subtract(Box3)
boundaries and excitations:
  Rad1: Radiation Objects=Box1
  1: Wave Port Objects=Rectangle1 WavePortType=Modal NumModes=1 Modes{Mode1{CharImp=Zpi}} SpecifiedWaveDirectionFlip
  2: Wave Port Objects=Rectangle2 WavePortType=Modal NumModes=1 Modes{Mode1{CharImp=Zpi}}
setups:
  Setup1: HfssDriven Frequency=1.575GHz MaxDeltaS=0.02 MaximumPasses=12 MinimumPasses=1 MinimumConvergedPasses=1 PercentRefinement=30 BasisOrder=1 PortAccuracy=2 DrivenSolverType="Direct Solver" InfiniteSphereSetup=1
    sweep Sweep: 0.7875GHz to 10GHz, 401 points; Type=Interpolating SaveFields InterpTolerance=0.5 InterpMaxSolns=250 PassivityErrorTolerance=0.0001
source amplitudes:
  1:1: 1V 0deg
  2:1: 0V 0deg
radiation setups:
  Infinite Sphere1: Infinite Sphere Theta=0deg..180deg step 2deg Phi=-180deg..180deg step 2deg
reports:
  Terminal S Parameter Plot1: dB(St(1,1)), dB(St(2,1)), dB(St(1,2)), dB(St(2,2)) vs Freq on Setup1 : Sweep; markers m1 at 1.5705625GHz
  Gain Plot1: dB(GainTotal) vs Phi, Theta on Setup1 : LastAdaptive, Infinite Sphere1 [Freq=1.575GHz]

# Ansys Electronics Desktop project, version 2025.2
project variables:
  $Radius = 73mm
  $RadLen = 35mm  # optimise 10mm..35mm
  $RadWidth = 1.5mm
  $FeedX = 65mm+$FeedOffset
  $FeedY = 20mm
  $LineWidth = 1.5mm
  $LineGap = 0.19mm
  $TESTwidth = 1.5mm
  $TESTgap = 0.19mm
  $FeedOffset = 15mm  # optimise 2.5mm..7.5mm
  $Angle = 0deg
materials:
  vacuum: permittivity=1
  copper: permeability=0.999991 conductivity=58000000
  air: permittivity=1.0006 permeability=1.0000004
  graphite: conductivity=70000
  FR4_epoxy: permittivity=4.4 dielectric_loss_tangent=0.02
  cast_iron: permeability=60 conductivity=1500000
  CF - Carbon fiber: conductivity=252.337
  aluminum: permeability=1.000021 conductivity=38000000
  cyanate_ester: permittivity=3.8

design HFSSDesign1 (HFSS, HFSS Terminal Network, model units mm)
geometry:
  Substrate [FR4_epoxy] = box(corner=(48mm, $Radius, 0.8mm), size=((-4.25*25) mm, 48mm, -1.6mm))
  Box13 [air] = box(corner=(-200mm, 200mm, 100mm), size=(400mm, -200mm, -200mm))
  Coupler [aluminum, non-model] = cylinder(axis=X, base_centre=(-100mm, 0mm, 0mm), radius=70.6mm, height=200mm, segments=32)
  Cylinder5 = cylinder(axis=X, base_centre=(100mm, 0mm, 0mm), radius=(70.6-3.175) mm, height=-200mm)
  Coupler.subtract(Cylinder5)
  Substrate.chamfer(Edges=Substrate.edge(at (-58.25, 121, 0)) LeftDistance=48mm RightDistance="(2.25*25) mm" ChamferType="Left Distance-Right Distance" ChamferAdditionalGeometryInfo{ChamferEdgeGeometryInfo{ChamferEdgeID=1342 ChamferEdgeSense ChamferEdgeStart{X=-58.25mm Y=121mm Z=0.8mm} ChamferEdgeEnd{X=-58.25mm Y=121mm Z=-0.8mm} ChamferEdgeMid{X=-58.25mm Y=121mm Z=0mm} ChamferEdgeMidTangent(0, 0, -1)}})
  Substrate.chamfer(Edges=Substrate.edge(at (48, 121, 0)) LeftDistance=6.25mm RightDistance=48mm ChamferType="Left Distance-Right Distance" ChamferAdditionalGeometryInfo{ChamferEdgeGeometryInfo{ChamferEdgeID=1343 ChamferEdgeSense ChamferEdgeStart{X=48mm Y=121mm Z=0.8mm} ChamferEdgeEnd{X=48mm Y=121mm Z=-0.8mm} ChamferEdgeMid{X=48mm Y=121mm Z=0mm} ChamferEdgeMidTangent(0, 0, -1)}})
  Fintenna [cyanate_ester] = imported_body(C:\Users\Garrett W\Documents\[A3-FIN] fintenna_assembly\[A3-FIN] fintenna_assembly - Fintenna.step)
  Fintenna.rotate(axis=Z, angle=90deg)
  Fintenna.rotate(axis=Y, angle=-90deg)
  Fintenna.move(-62.5mm, 73mm, -2.38125mm)
  Box14 = box(corner=(-58.25mm, $Radius, 0.8mm), size=(106.25mm, -12mm, -1.6mm))
  Substrate.unite(Box14)
  Fintenna_1 = Fintenna.copy()
  Fintenna_1.delete()
  Substrate_1 = Substrate.copy()
  Substrate_1.delete()
  FinFoot1 [aluminum, non-model] = imported_body(C:\Users\Garrett W\Documents\[A3-FIN] fintenna_assembly\[A3-FIN] fintenna_assembly - Part 1.step)
  FinFoot [aluminum, non-model] = imported_body(C:\Users\Garrett W\Documents\[A3-FIN] fintenna_assembly\[A3-FIN] fintenna_assembly - Part 2.step)
  FinFoot1.rotate(axis=Y, angle=-90deg)
  FinFoot1.rotate(axis=Z, angle=90deg)
  FinFoot1.move(-62.5mm, 70.46mm, 2.38125mm)
  FinFoot.rotate(axis=Y, angle=-90deg)
  FinFoot.rotate(axis=Z, angle=90deg)
  FinFoot.move(-62.5mm, 70.46mm, 7.16915mm)
  CutTool = box(corner=(48mm, $Radius, 0.835mm), size=((-4.25*25) mm, 48mm, -1.67mm))
  CutTool.chamfer(Edges=CutTool.edge(at (-58.25, 121, 0)) LeftDistance=48mm RightDistance="(2.25*25) mm" ChamferType="Left Distance-Right Distance" ChamferAdditionalGeometryInfo{ChamferEdgeGeometryInfo{ChamferEdgeID=4487 ChamferEdgeSense ChamferEdgeStart{X=-58.25mm Y=121mm Z=0.835mm} ChamferEdgeEnd{X=-58.25mm Y=121mm Z=-0.835mm} ChamferEdgeMid{X=-58.25mm Y=121mm Z=0mm} ChamferEdgeMidTangent(0, 0, -1)}})
  CutTool.chamfer(Edges=CutTool.edge(at (48, 121, 0)) LeftDistance=6.25mm RightDistance=48mm ChamferType="Left Distance-Right Distance" ChamferAdditionalGeometryInfo{ChamferEdgeGeometryInfo{ChamferEdgeID=4488 ChamferEdgeSense ChamferEdgeStart{X=48mm Y=121mm Z=0.835mm} ChamferEdgeEnd{X=48mm Y=121mm Z=-0.835mm} ChamferEdgeMid{X=48mm Y=121mm Z=0mm} ChamferEdgeMidTangent(0, 0, -1)}})
  Box16 = box(corner=(-58.25mm, 73mm, 0.835mm), size=(106.25mm, -12.065mm, -1.67mm))
  CutTool.unite(Box16)
  CutTool_1 = CutTool.copy()
  FinFoot_1 = FinFoot.copy()
  FinFoot1_1 = FinFoot1.copy()
  Fintenna_2 = Fintenna.copy()
  Coupler.subtract(CutTool_1, FinFoot_1, FinFoot1_1, Fintenna_2)
  CutTool_2 = CutTool.copy()
  [CutTool, CutTool_2].delete()
  FinFoot_2 = FinFoot.copy()
  FinFoot_2.delete()
  FinFoot1_2 = FinFoot1.copy()
  FinFoot1_2.delete()
  Fintenna_3 = Fintenna.copy()
  Fintenna_3.delete()
  coordinate_system RelativeCS1 = origin=(-58.25mm, $Radius, 0.835mm) x=(1mm, 0mm, 0mm) y=(0mm, 1mm, 0mm)
  Copper [copper] = box(corner=(0mm, -12mm, 0mm), size=(105mm, 57.065mm, -0.035mm)) in RelativeCS1
  Copper.chamfer(Edges=Copper.edge(at (-58.25, 118.065, 0.8175)) LeftDistance=45mm RightDistance=55mm ChamferType="Left Distance-Right Distance" ChamferAdditionalGeometryInfo{ChamferEdgeGeometryInfo{ChamferEdgeID=6199 ChamferEdgeSense ChamferEdgeStart{X=-58.25mm Y=118.065mm Z=0.835mm} ChamferEdgeEnd{X=-58.25mm Y=118.065mm Z=0.8mm} ChamferEdgeMid{X=-58.25mm Y=118.065mm Z=0.8175mm} ChamferEdgeMidTangent(0, 0, -1)}})
  Copper.chamfer(Edges=Copper.edge(at (46.75, 118.065, 0.8175)) LeftDistance=5mm RightDistance=40mm ChamferType="Left Distance-Right Distance" ChamferAdditionalGeometryInfo{ChamferEdgeGeometryInfo{ChamferEdgeID=6200 ChamferEdgeSense ChamferEdgeStart{X=46.75mm Y=118.065mm Z=0.835mm} ChamferEdgeEnd{X=46.75mm Y=118.065mm Z=0.8mm} ChamferEdgeMid{X=46.75mm Y=118.065mm Z=0.8175mm} ChamferEdgeMidTangent(0, 0, -1)}})
  LeftSlot = box(corner=($FeedX, $FeedY, 0mm), size=(-($RadLen+$FeedOffset), $RadWidth, -0.035mm)) in RelativeCS1
  RightSlot = box(corner=($FeedX+$LineWidth, $FeedY, 0mm), size=($RadLen-$FeedOffset, $RadWidth, -0.035mm)) in RelativeCS1
  LeftWaveguide = box(corner=($FeedX, $FeedY, 0mm), size=(-$LineGap, -($FeedY+12mm), -0.035mm)) in RelativeCS1
  RightWaveguide = box(corner=($FeedX+$LineWidth, $FeedY, 0mm), size=($LineGap, -($FeedY+12mm), -0.035mm)) in RelativeCS1
  Copper_1 = Copper.copy()
  Substrate_2 = Substrate.copy()
  Fintenna.subtract(Copper_1, Substrate_2)
  Rectangle1 = rectangle(corner=($FeedX-10mm, -12mm, (-0.035-5) mm), z_size=10mm, x_size=20mm) in RelativeCS1
  Substrate.move_faces(MoveAlongNormalFlag=true OffsetDistance=15mm FacesToMove=Substrate.face(at (44.875, 97, 0), at (48, 67, 0))) in RelativeCS1  # suppressed
  Copper.move_faces(MoveAlongNormalFlag=true OffsetDistance=15mm FacesToMove=Copper.face(at (46.75, 69.5325, 0.8175), at (44.25, 98.065, 0.8175))) in RelativeCS1  # suppressed
  coordinate_system LeftAngleRotate = origin=($FeedX, $FeedY, -0.035mm) x=(1mm, 0mm, 0mm) y=(0mm, 1mm, 0mm) in RelativeCS1
  coordinate_system RightAngleRotate = origin=($FeedX+$LineWidth, $FeedY, 0mm) x=(1mm, 0mm, 0mm) y=(0mm, 1mm, 0mm) in RelativeCS1
  LeftSlot.rotate(axis=Z, angle=$angle) in LeftAngleRotate
  RightSlot.rotate(axis=Z, angle=$angle) in RightAngleRotate
  RightWaveguide.move_faces(MoveAlongNormalFlag=true OffsetDistance=$LineGap*tan($Angle) FacesToMove=RightWaveguide.face(at (23.345, 93, 0.8175))) in RightAngleRotate
  Copper.subtract(LeftSlot, LeftWaveguide, RightSlot, RightWaveguide)
  Box17 = box(corner=(-200mm, -80mm, -80mm), size=(400mm, 80mm, 160mm))
  Box17.delete()
  Fuselage [CF - Carbon fiber] = imported_body()
  group Fintenna1 = Fintenna
  group Part2 = FinFoot1
  group Part3 = FinFoot
boundaries and excitations:
  Rad1: Radiation Objects=Box13
  1: Wave Port Objects=Rectangle1 WavePortType=Modal NumModes=1 Modes{Mode1{CharImp=Zpi}} SpecifiedWaveDirectionFlip
mesh:
  initial mesh: GlobalSurfApproximation{CurvedSurfaceApproxChoice=UseSlider SliderMeshSettings=1} GlobalCurvilinear{Apply} MeshMethod=AnsoftClassic DynamicSurfaceResolution
setups:
  Setup1: HfssDriven Frequency=1.575GHz MaxDeltaS=0.02 MaximumPasses=8 MinimumPasses=1 MinimumConvergedPasses=1 PercentRefinement=30 BasisOrder=1 PortAccuracy=2 DrivenSolverType="Direct Solver" InfiniteSphereSetup=69
    sweep Sweep: 1000MHz to 2000MHz, 120 points; disabled Type=Interpolating SaveFields InterpTolerance=0.5 InterpMaxSolns=50 PassivityErrorTolerance=0.0001
    sweep Sweep1: 1.5GHz to 1.6GHz, 200 points; disabled Type=Discrete
    sweep QuickWideSweep: 1GHz to 10GHz, 401 points; Type=Interpolating SaveFields InterpTolerance=0.5 InterpMaxSolns=250 PassivityErrorTolerance=0.0001
    sweep QuickNarrowSweep: 1GHz to 2GHz, 80 points; disabled Type=Interpolating InterpTolerance=0.5 InterpMaxSolns=250 PassivityErrorTolerance=0.0001
source amplitudes:
  1:1: 1V 0deg
optimetrics:
  OptimizationSetup1: Optimization disabled Optimizer="kDX ASO" AnalysisStopOptions{StopForNumIteration MaxNumIteration=32 MinNumIteration=10} CostFuncNormType=L2 Acceptable_Cost=0 Noise=0.0001 UpdateDesignWhenDone
    vary $FeedOffset: Min=0mm Max=15mm MinStep=0.05mm MaxStep=0.5mm MinFocus=2.5mm MaxFocus=7.5mm start=0mm
    vary $RadLen: Min=15.5mm Max=35mm MinStep=0.35mm MaxStep=3.5mm MinFocus=10mm MaxFocus=35mm start=35mm
    goal dB(St(1,1)) Minimize 0 weight 1 on Setup1 : LastAdaptive at Freq 1.575GHz to 1.575GHz
radiation setups:
  Infinite Sphere1: Infinite Sphere Theta=0deg..180deg step 2deg Phi=-180deg..180deg step 2deg
reports:
  Gain Plot1: dB(GainTotal) vs Phi, Theta on Setup1 : LastAdaptive, Infinite Sphere1 [Freq=1.575GHz]
  Gain Plot2: dB(GainRHCP) vs Phi, Theta on Setup1 : LastAdaptive, Infinite Sphere1 [Freq=1.575GHz]
  Axial Ratio Plot1: mag(AxialRatioValue) vs Freq on Setup1 : LastAdaptive, Infinite Sphere1 [Phi=90deg Theta=180deg]
  VSWR Plot1: VSWR(1) vs Freq on Setup1 : QuickWideSweep
  S Parameter Plot1: dB(S(1,1)) vs Freq on Setup1 : QuickWideSweep

design HFSSDesign2 (HFSS, HFSS Terminal Network, model units mm)
geometry:
  Substrate [FR4_epoxy] = box(corner=(-20mm, 0mm, 0mm), size=(40mm, 40mm, 0.8mm))
  Copper [copper] = box(corner=(-20mm, 0mm, 0.8mm), size=(40mm, 40mm, 0.035mm))
  Slot2 = box(corner=($TESTwidth/2, 0mm, 0.8mm), size=($TESTgap, 40mm, 0.035mm))
  Slot1 = box(corner=(-$TESTwidth/2, 0mm, 0.8mm), size=(-$TESTgap, 40mm, 0.035mm))
  Copper.subtract(Slot1, Slot2)
  Rectangle1 = rectangle(corner=(-5mm, 0mm, -4mm), z_size=10mm, x_size=10mm)
  Rectangle2 = rectangle(corner=(-5mm, 40mm, -4mm), z_size=10mm, x_size=10mm)
  Box1 [vacuum] = box(corner=(-40mm, -20mm, -40mm), size=(80mm, 80mm, 80mm))
  Box2 [CF - Carbon fiber] = box(corner=(-25mm, 20mm, -25mm), size=(50mm, 1mm, 50mm))
  Box3 = box(corner=(-20mm, 20mm, -0.3mm), size=(40mm, 1mm, 2.5mm))
  Box2.subtract(Box3)
boundaries and excitations:
  Rad1: Radiation Objects=Box1
  1: Wave Port Objects=Rectangle1 WavePortType=Modal NumModes=1 Modes{Mode1{CharImp=Zpi}} SpecifiedWaveDirectionFlip
  2: Wave Port Objects=Rectangle2 WavePortType=Modal NumModes=1 Modes{Mode1{CharImp=Zpi}}
setups:
  Setup1: HfssDriven Frequency=1.575GHz MaxDeltaS=0.02 MaximumPasses=12 MinimumPasses=1 MinimumConvergedPasses=1 PercentRefinement=30 BasisOrder=1 PortAccuracy=2 DrivenSolverType="Direct Solver" InfiniteSphereSetup=1
    sweep Sweep: 0.7875GHz to 10GHz, 401 points; Type=Interpolating SaveFields InterpTolerance=0.5 InterpMaxSolns=250 PassivityErrorTolerance=0.0001
source amplitudes:
  1:1: 1V 0deg
  2:1: 0V 0deg
radiation setups:
  Infinite Sphere1: Infinite Sphere Theta=0deg..180deg step 2deg Phi=-180deg..180deg step 2deg
reports:
  Terminal S Parameter Plot1: dB(St(1,1)), dB(St(2,1)), dB(St(1,2)), dB(St(2,2)) vs Freq on Setup1 : Sweep; markers m1 at 1.5705625GHz
  Gain Plot1: dB(GainTotal) vs Phi, Theta on Setup1 : LastAdaptive, Infinite Sphere1 [Freq=1.575GHz]
